.title scikit_digits_dense_io_hinge
.include "/home/ma-lab/Desktop/pyclln-final/device_model/nmos_lvl1_ald1106.lib"
.options klu
VMINUS 1 0 0.0000000000000000
VPLUS  2 0 0.4500000000000000
VIN0 13 0 0
VIN1 14 0 0
VIN2 15 0 0
VIN3 16 0 0
VIN4 17 0 0
VIN5 18 0 0
VIN6 19 0 0
VIN7 20 0 0
VIN8 21 0 0
VIN9 22 0 0
VIN10 23 0 0
VIN11 24 0 0
VIN12 25 0 0
VIN13 26 0 0
VIN14 27 0 0
VIN15 28 0 0
VIN16 29 0 0
VIN17 30 0 0
VIN18 31 0 0
VIN19 32 0 0
VIN20 33 0 0
VIN21 34 0 0
VIN22 35 0 0
VIN23 36 0 0
VIN24 37 0 0
VIN25 38 0 0
VIN26 39 0 0
VIN27 40 0 0
VIN28 41 0 0
VIN29 42 0 0
VIN30 43 0 0
VIN31 44 0 0
VIN32 45 0 0
VIN33 46 0 0
VIN34 47 0 0
VIN35 48 0 0
VIN36 49 0 0
VIN37 50 0 0
VIN38 51 0 0
VIN39 52 0 0
VIN40 53 0 0
VIN41 54 0 0
VIN42 55 0 0
VIN43 56 0 0
VIN44 57 0 0
VIN45 58 0 0
VIN46 59 0 0
VIN47 60 0 0
VIN48 61 0 0
VIN49 62 0 0
VIN50 63 0 0
VIN51 64 0 0
VIN52 65 0 0
VIN53 66 0 0
VIN54 67 0 0
VIN55 68 0 0
VIN56 69 0 0
VIN57 70 0 0
VIN58 71 0 0
VIN59 72 0 0
VIN60 73 0 0
VIN61 74 0 0
VIN62 75 0 0
VIN63 76 0 0
RS1 3 77 1e+09
RS2 4 78 1e+09
RS3 5 79 1e+09
RS4 6 80 1e+09
RS5 7 81 1e+09
RS6 8 82 1e+09
RS7 9 83 1e+09
RS8 10 84 1e+09
RS9 11 85 1e+09
RS10 12 86 1e+09
VOUT0 77 0 0
VOUT1 78 0 0
VOUT2 79 0 0
VOUT3 80 0 0
VOUT4 81 0 0
VOUT5 82 0 0
VOUT6 83 0 0
VOUT7 84 0 0
VOUT8 85 0 0
VOUT9 86 0 0
VG0 g0 0 1.7309885298195085
X0 13 g0 3 b0 NMOSWRAP
VG1 g1 0 0.8083340216127555
X1 13 g1 4 b1 NMOSWRAP
VG2 g2 0 1.9867405752270955
X2 13 g2 5 b2 NMOSWRAP
VG3 g3 0 1.7294753833911229
X3 13 g3 6 b3 NMOSWRAP
VG4 g4 0 1.6958275546968502
X4 13 g4 7 b4 NMOSWRAP
VG5 g5 0 1.4932533472587168
X5 13 g5 8 b5 NMOSWRAP
VG6 g6 0 1.2104594265851456
X6 13 g6 9 b6 NMOSWRAP
VG7 g7 0 2.1433596742889933
X7 13 g7 10 b7 NMOSWRAP
VG8 g8 0 1.4242230157676770
X8 13 g8 11 b8 NMOSWRAP
VG9 g9 0 1.3503613689814500
X9 13 g9 12 b9 NMOSWRAP
VG10 g10 0 2.1475511237309135
X10 14 g10 3 b10 NMOSWRAP
VG11 g11 0 1.9405697121233378
X11 14 g11 4 b11 NMOSWRAP
VG12 g12 0 1.0528048770261005
X12 14 g12 5 b12 NMOSWRAP
VG13 g13 0 1.9055507728479295
X13 14 g13 6 b13 NMOSWRAP
VG14 g14 0 1.1649896977055594
X14 14 g14 7 b14 NMOSWRAP
VG15 g15 0 2.5170040825875155
X15 14 g15 8 b15 NMOSWRAP
VG16 g16 0 2.6714444084388500
X16 14 g16 9 b16 NMOSWRAP
VG17 g17 0 1.8620328841093376
X17 14 g17 10 b17 NMOSWRAP
VG18 g18 0 2.6547633420543031
X18 14 g18 11 b18 NMOSWRAP
VG19 g19 0 0.9292023232703872
X19 14 g19 12 b19 NMOSWRAP
VG20 g20 0 1.8868037027738338
X20 15 g20 3 b20 NMOSWRAP
VG21 g21 0 0.8968946348704757
X21 15 g21 4 b21 NMOSWRAP
VG22 g22 0 1.7132752370941262
X22 15 g22 5 b22 NMOSWRAP
VG23 g23 0 0.9671945602363783
X23 15 g23 6 b23 NMOSWRAP
VG24 g24 0 1.0361099363278743
X24 15 g24 7 b24 NMOSWRAP
VG25 g25 0 2.0926769452018403
X25 15 g25 8 b25 NMOSWRAP
VG26 g26 0 1.2585270013595307
X26 15 g26 9 b26 NMOSWRAP
VG27 g27 0 0.9906277896974617
X27 15 g27 10 b27 NMOSWRAP
VG28 g28 0 1.2456889659087593
X28 15 g28 11 b28 NMOSWRAP
VG29 g29 0 1.5371091412574234
X29 15 g29 12 b29 NMOSWRAP
VG30 g30 0 1.8025218403101755
X30 16 g30 3 b30 NMOSWRAP
VG31 g31 0 1.2039222590961720
X31 16 g31 4 b31 NMOSWRAP
VG32 g32 0 2.1909151317335582
X32 16 g32 5 b32 NMOSWRAP
VG33 g33 0 1.8369071299914412
X33 16 g33 6 b33 NMOSWRAP
VG34 g34 0 1.8867826200417355
X34 16 g34 7 b34 NMOSWRAP
VG35 g35 0 1.6205084650167585
X35 16 g35 8 b35 NMOSWRAP
VG36 g36 0 2.5356842724935484
X36 16 g36 9 b36 NMOSWRAP
VG37 g37 0 2.0550094024750649
X37 16 g37 10 b37 NMOSWRAP
VG38 g38 0 1.1151718466302061
X38 16 g38 11 b38 NMOSWRAP
VG39 g39 0 2.3266927798661015
X39 16 g39 12 b39 NMOSWRAP
VG40 g40 0 2.9202399302008240
X40 17 g40 3 b40 NMOSWRAP
VG41 g41 0 1.8750188126329876
X41 17 g41 4 b41 NMOSWRAP
VG42 g42 0 2.7514201438788262
X42 17 g42 5 b42 NMOSWRAP
VG43 g43 0 1.5186307185099968
X43 17 g43 6 b43 NMOSWRAP
VG44 g44 0 2.0260742871623458
X44 17 g44 7 b44 NMOSWRAP
VG45 g45 0 1.7119784174162476
X45 17 g45 8 b45 NMOSWRAP
VG46 g46 0 1.7326813418102978
X46 17 g46 9 b46 NMOSWRAP
VG47 g47 0 2.4972581662434754
X47 17 g47 10 b47 NMOSWRAP
VG48 g48 0 1.9551093903697268
X48 17 g48 11 b48 NMOSWRAP
VG49 g49 0 2.8959200106259502
X49 17 g49 12 b49 NMOSWRAP
VG50 g50 0 1.9744683603332298
X50 18 g50 3 b50 NMOSWRAP
VG51 g51 0 0.9347135751188058
X51 18 g51 4 b51 NMOSWRAP
VG52 g52 0 1.5742704037687960
X52 18 g52 5 b52 NMOSWRAP
VG53 g53 0 2.6644136340101285
X53 18 g53 6 b53 NMOSWRAP
VG54 g54 0 1.6641188468578894
X54 18 g54 7 b54 NMOSWRAP
VG55 g55 0 0.8112053232634115
X55 18 g55 8 b55 NMOSWRAP
VG56 g56 0 1.3061487877440450
X56 18 g56 9 b56 NMOSWRAP
VG57 g57 0 0.9010748341581480
X57 18 g57 10 b57 NMOSWRAP
VG58 g58 0 2.9861670256978639
X58 18 g58 11 b58 NMOSWRAP
VG59 g59 0 2.9338057050986404
X59 18 g59 12 b59 NMOSWRAP
VG60 g60 0 2.5505812900483202
X60 19 g60 3 b60 NMOSWRAP
VG61 g61 0 2.1040885231623019
X61 19 g61 4 b61 NMOSWRAP
VG62 g62 0 2.4711596860162834
X62 19 g62 5 b62 NMOSWRAP
VG63 g63 0 1.1307572548144003
X63 19 g63 6 b63 NMOSWRAP
VG64 g64 0 1.4093022715937396
X64 19 g64 7 b64 NMOSWRAP
VG65 g65 0 1.9291504694258195
X65 19 g65 8 b65 NMOSWRAP
VG66 g66 0 1.5524046325262075
X66 19 g66 9 b66 NMOSWRAP
VG67 g67 0 0.8527776718021501
X67 19 g67 10 b67 NMOSWRAP
VG68 g68 0 2.9620952520537287
X68 19 g68 11 b68 NMOSWRAP
VG69 g69 0 1.7430485685484052
X69 19 g69 12 b69 NMOSWRAP
VG70 g70 0 1.8840009886030935
X70 20 g70 3 b70 NMOSWRAP
VG71 g71 0 1.4779679644530723
X71 20 g71 4 b71 NMOSWRAP
VG72 g72 0 1.3344256936810583
X72 20 g72 5 b72 NMOSWRAP
VG73 g73 0 1.6205022419717154
X73 20 g73 6 b73 NMOSWRAP
VG74 g74 0 2.6220380241776269
X74 20 g74 7 b74 NMOSWRAP
VG75 g75 0 2.4076808766460038
X75 20 g75 8 b75 NMOSWRAP
VG76 g76 0 1.6032237756186842
X76 20 g76 9 b76 NMOSWRAP
VG77 g77 0 0.7792890075627389
X77 20 g77 10 b77 NMOSWRAP
VG78 g78 0 2.5441611128233355
X78 20 g78 11 b78 NMOSWRAP
VG79 g79 0 1.3561247945916777
X79 20 g79 12 b79 NMOSWRAP
VG80 g80 0 2.0610409991903280
X80 21 g80 3 b80 NMOSWRAP
VG81 g81 0 0.8074896191618087
X81 21 g81 4 b81 NMOSWRAP
VG82 g82 0 2.2399545433537331
X82 21 g82 5 b82 NMOSWRAP
VG83 g83 0 1.6219277082148833
X83 21 g83 6 b83 NMOSWRAP
VG84 g84 0 1.8684160471526534
X84 21 g84 7 b84 NMOSWRAP
VG85 g85 0 1.6835381340930462
X85 21 g85 8 b85 NMOSWRAP
VG86 g86 0 1.5394617779286910
X86 21 g86 9 b86 NMOSWRAP
VG87 g87 0 1.9897002869799434
X87 21 g87 10 b87 NMOSWRAP
VG88 g88 0 2.9390490522183561
X88 21 g88 11 b88 NMOSWRAP
VG89 g89 0 1.0037464842856609
X89 21 g89 12 b89 NMOSWRAP
VG90 g90 0 1.4548316889668556
X90 22 g90 3 b90 NMOSWRAP
VG91 g91 0 0.8440448470844476
X91 22 g91 4 b91 NMOSWRAP
VG92 g92 0 2.4113994568970258
X92 22 g92 5 b92 NMOSWRAP
VG93 g93 0 2.2294028722328489
X93 22 g93 6 b93 NMOSWRAP
VG94 g94 0 1.2329304293998957
X94 22 g94 7 b94 NMOSWRAP
VG95 g95 0 1.6876952404395085
X95 22 g95 8 b95 NMOSWRAP
VG96 g96 0 2.1986443518334386
X96 22 g96 9 b96 NMOSWRAP
VG97 g97 0 2.2383329851097429
X97 22 g97 10 b97 NMOSWRAP
VG98 g98 0 1.1335735503384841
X98 22 g98 11 b98 NMOSWRAP
VG99 g99 0 2.7337175304342343
X99 22 g99 12 b99 NMOSWRAP
VG100 g100 0 2.5005183595690537
X100 23 g100 3 b100 NMOSWRAP
VG101 g101 0 1.0513969683863049
X101 23 g101 4 b101 NMOSWRAP
VG102 g102 0 2.7050624094721774
X102 23 g102 5 b102 NMOSWRAP
VG103 g103 0 2.4347502261229224
X103 23 g103 6 b103 NMOSWRAP
VG104 g104 0 2.5468177217229320
X104 23 g104 7 b104 NMOSWRAP
VG105 g105 0 1.9725267688137811
X105 23 g105 8 b105 NMOSWRAP
VG106 g106 0 1.2468853088882892
X106 23 g106 9 b106 NMOSWRAP
VG107 g107 0 2.8165319548266012
X107 23 g107 10 b107 NMOSWRAP
VG108 g108 0 2.0821902997493469
X108 23 g108 11 b108 NMOSWRAP
VG109 g109 0 1.5290352962740794
X109 23 g109 12 b109 NMOSWRAP
VG110 g110 0 1.3435016908800446
X110 24 g110 3 b110 NMOSWRAP
VG111 g111 0 2.8063098236215471
X111 24 g111 4 b111 NMOSWRAP
VG112 g112 0 1.6944047879403465
X112 24 g112 5 b112 NMOSWRAP
VG113 g113 0 1.9654309102510443
X113 24 g113 6 b113 NMOSWRAP
VG114 g114 0 2.1189948550613615
X114 24 g114 7 b114 NMOSWRAP
VG115 g115 0 2.6090621139768553
X115 24 g115 8 b115 NMOSWRAP
VG116 g116 0 2.1530171652647940
X116 24 g116 9 b116 NMOSWRAP
VG117 g117 0 1.1476023635649586
X117 24 g117 10 b117 NMOSWRAP
VG118 g118 0 2.0803290434704782
X118 24 g118 11 b118 NMOSWRAP
VG119 g119 0 1.8508488757384332
X119 24 g119 12 b119 NMOSWRAP
VG120 g120 0 1.9827925052033475
X120 25 g120 3 b120 NMOSWRAP
VG121 g121 0 2.3239213945287336
X121 25 g121 4 b121 NMOSWRAP
VG122 g122 0 1.3030751187842942
X122 25 g122 5 b122 NMOSWRAP
VG123 g123 0 1.1699110775695805
X123 25 g123 6 b123 NMOSWRAP
VG124 g124 0 0.9988120825413624
X124 25 g124 7 b124 NMOSWRAP
VG125 g125 0 1.3666333182061208
X125 25 g125 8 b125 NMOSWRAP
VG126 g126 0 0.7730625886490795
X126 25 g126 9 b126 NMOSWRAP
VG127 g127 0 2.1660593763665599
X127 25 g127 10 b127 NMOSWRAP
VG128 g128 0 1.4141376867444206
X128 25 g128 11 b128 NMOSWRAP
VG129 g129 0 1.1713947255792698
X129 25 g129 12 b129 NMOSWRAP
VG130 g130 0 0.9643981175868084
X130 26 g130 3 b130 NMOSWRAP
VG131 g131 0 1.3884505667968230
X131 26 g131 4 b131 NMOSWRAP
VG132 g132 0 1.2335798642940643
X132 26 g132 5 b132 NMOSWRAP
VG133 g133 0 1.3926084012995301
X133 26 g133 6 b133 NMOSWRAP
VG134 g134 0 1.8106721793067777
X134 26 g134 7 b134 NMOSWRAP
VG135 g135 0 1.9863678474489181
X135 26 g135 8 b135 NMOSWRAP
VG136 g136 0 2.6515045100430785
X136 26 g136 9 b136 NMOSWRAP
VG137 g137 0 2.9741468267643696
X137 26 g137 10 b137 NMOSWRAP
VG138 g138 0 0.8599531940160405
X138 26 g138 11 b138 NMOSWRAP
VG139 g139 0 1.2722660657313689
X139 26 g139 12 b139 NMOSWRAP
VG140 g140 0 2.1974507113085293
X140 27 g140 3 b140 NMOSWRAP
VG141 g141 0 1.1132997665062727
X141 27 g141 4 b141 NMOSWRAP
VG142 g142 0 2.7078282600802535
X142 27 g142 5 b142 NMOSWRAP
VG143 g143 0 1.2391554591863083
X143 27 g143 6 b143 NMOSWRAP
VG144 g144 0 2.4189488374877604
X144 27 g144 7 b144 NMOSWRAP
VG145 g145 0 2.2192961547699772
X145 27 g145 8 b145 NMOSWRAP
VG146 g146 0 2.5474924008854165
X146 27 g146 9 b146 NMOSWRAP
VG147 g147 0 0.8203070150968386
X147 27 g147 10 b147 NMOSWRAP
VG148 g148 0 1.2665415646747766
X148 27 g148 11 b148 NMOSWRAP
VG149 g149 0 2.3354118730210329
X149 27 g149 12 b149 NMOSWRAP
VG150 g150 0 0.9470156452525264
X150 28 g150 3 b150 NMOSWRAP
VG151 g151 0 0.8188263371872184
X151 28 g151 4 b151 NMOSWRAP
VG152 g152 0 1.5535536008240116
X152 28 g152 5 b152 NMOSWRAP
VG153 g153 0 2.0770094808114683
X153 28 g153 6 b153 NMOSWRAP
VG154 g154 0 0.8675011366143606
X154 28 g154 7 b154 NMOSWRAP
VG155 g155 0 0.8977432489643494
X155 28 g155 8 b155 NMOSWRAP
VG156 g156 0 0.8478776686343602
X156 28 g156 9 b156 NMOSWRAP
VG157 g157 0 1.6390892065518836
X157 28 g157 10 b157 NMOSWRAP
VG158 g158 0 2.2539608535361300
X158 28 g158 11 b158 NMOSWRAP
VG159 g159 0 1.1955610015863816
X159 28 g159 12 b159 NMOSWRAP
VG160 g160 0 2.7215995163343578
X160 29 g160 3 b160 NMOSWRAP
VG161 g161 0 1.7228754647509066
X161 29 g161 4 b161 NMOSWRAP
VG162 g162 0 2.1441932933474206
X162 29 g162 5 b162 NMOSWRAP
VG163 g163 0 1.4034601716037238
X163 29 g163 6 b163 NMOSWRAP
VG164 g164 0 2.1343227902946218
X164 29 g164 7 b164 NMOSWRAP
VG165 g165 0 2.8957349153602259
X165 29 g165 8 b165 NMOSWRAP
VG166 g166 0 1.7580331121792017
X166 29 g166 9 b166 NMOSWRAP
VG167 g167 0 1.2158621360699571
X167 29 g167 10 b167 NMOSWRAP
VG168 g168 0 1.7070764067871196
X168 29 g168 11 b168 NMOSWRAP
VG169 g169 0 1.7502920957184549
X169 29 g169 12 b169 NMOSWRAP
VG170 g170 0 1.8921393450119131
X170 30 g170 3 b170 NMOSWRAP
VG171 g171 0 1.9328998120746554
X171 30 g171 4 b171 NMOSWRAP
VG172 g172 0 0.8454656817357288
X172 30 g172 5 b172 NMOSWRAP
VG173 g173 0 1.1199429438827702
X173 30 g173 6 b173 NMOSWRAP
VG174 g174 0 1.7630111541390898
X174 30 g174 7 b174 NMOSWRAP
VG175 g175 0 2.3429351338925715
X175 30 g175 8 b175 NMOSWRAP
VG176 g176 0 2.4995727936874506
X176 30 g176 9 b176 NMOSWRAP
VG177 g177 0 2.4984817488067006
X177 30 g177 10 b177 NMOSWRAP
VG178 g178 0 1.8812521931457482
X178 30 g178 11 b178 NMOSWRAP
VG179 g179 0 2.9026820849413069
X179 30 g179 12 b179 NMOSWRAP
VG180 g180 0 1.4967158532147207
X180 31 g180 3 b180 NMOSWRAP
VG181 g181 0 1.8332808652785748
X181 31 g181 4 b181 NMOSWRAP
VG182 g182 0 2.4338414985173316
X182 31 g182 5 b182 NMOSWRAP
VG183 g183 0 2.6801389164889065
X183 31 g183 6 b183 NMOSWRAP
VG184 g184 0 1.6825351240490509
X184 31 g184 7 b184 NMOSWRAP
VG185 g185 0 2.6595401571014774
X185 31 g185 8 b185 NMOSWRAP
VG186 g186 0 1.7502846189390957
X186 31 g186 9 b186 NMOSWRAP
VG187 g187 0 2.3604309396442971
X187 31 g187 10 b187 NMOSWRAP
VG188 g188 0 0.7690088180523444
X188 31 g188 11 b188 NMOSWRAP
VG189 g189 0 0.8067032032591852
X189 31 g189 12 b189 NMOSWRAP
VG190 g190 0 2.8660136104696994
X190 32 g190 3 b190 NMOSWRAP
VG191 g191 0 0.9798103835201853
X191 32 g191 4 b191 NMOSWRAP
VG192 g192 0 2.2394275284893421
X192 32 g192 5 b192 NMOSWRAP
VG193 g193 0 1.3873321735975219
X193 32 g193 6 b193 NMOSWRAP
VG194 g194 0 1.2018952734947521
X194 32 g194 7 b194 NMOSWRAP
VG195 g195 0 1.6237519097582080
X195 32 g195 8 b195 NMOSWRAP
VG196 g196 0 2.8332785921441235
X196 32 g196 9 b196 NMOSWRAP
VG197 g197 0 2.0331169719391182
X197 32 g197 10 b197 NMOSWRAP
VG198 g198 0 2.8126078769052358
X198 32 g198 11 b198 NMOSWRAP
VG199 g199 0 2.3300945418443808
X199 32 g199 12 b199 NMOSWRAP
VG200 g200 0 1.8777370162959457
X200 33 g200 3 b200 NMOSWRAP
VG201 g201 0 1.8886953754034375
X201 33 g201 4 b201 NMOSWRAP
VG202 g202 0 1.2423467692410886
X202 33 g202 5 b202 NMOSWRAP
VG203 g203 0 0.7604929261538622
X203 33 g203 6 b203 NMOSWRAP
VG204 g204 0 1.6901315490061104
X204 33 g204 7 b204 NMOSWRAP
VG205 g205 0 2.0175962482628291
X205 33 g205 8 b205 NMOSWRAP
VG206 g206 0 2.7222642039524860
X206 33 g206 9 b206 NMOSWRAP
VG207 g207 0 2.2745658905127963
X207 33 g207 10 b207 NMOSWRAP
VG208 g208 0 2.6452493537328103
X208 33 g208 11 b208 NMOSWRAP
VG209 g209 0 2.8338628955810701
X209 33 g209 12 b209 NMOSWRAP
VG210 g210 0 2.8675107156756501
X210 34 g210 3 b210 NMOSWRAP
VG211 g211 0 2.5860430918298865
X211 34 g211 4 b211 NMOSWRAP
VG212 g212 0 1.0456378623287486
X212 34 g212 5 b212 NMOSWRAP
VG213 g213 0 1.5299175337280939
X213 34 g213 6 b213 NMOSWRAP
VG214 g214 0 1.2191306126824255
X214 34 g214 7 b214 NMOSWRAP
VG215 g215 0 2.7016084586021778
X215 34 g215 8 b215 NMOSWRAP
VG216 g216 0 2.5327429934390802
X216 34 g216 9 b216 NMOSWRAP
VG217 g217 0 1.5352536915386836
X217 34 g217 10 b217 NMOSWRAP
VG218 g218 0 2.0305661971251796
X218 34 g218 11 b218 NMOSWRAP
VG219 g219 0 2.5615459655753288
X219 34 g219 12 b219 NMOSWRAP
VG220 g220 0 2.6246128006514464
X220 35 g220 3 b220 NMOSWRAP
VG221 g221 0 1.2130357731376620
X221 35 g221 4 b221 NMOSWRAP
VG222 g222 0 2.3940304511837600
X222 35 g222 5 b222 NMOSWRAP
VG223 g223 0 2.5576818693587602
X223 35 g223 6 b223 NMOSWRAP
VG224 g224 0 0.8470403317950661
X224 35 g224 7 b224 NMOSWRAP
VG225 g225 0 0.9911716595210548
X225 35 g225 8 b225 NMOSWRAP
VG226 g226 0 1.7289382121823622
X226 35 g226 9 b226 NMOSWRAP
VG227 g227 0 1.2469827491866743
X227 35 g227 10 b227 NMOSWRAP
VG228 g228 0 2.7313996488727819
X228 35 g228 11 b228 NMOSWRAP
VG229 g229 0 2.3692969598799252
X229 35 g229 12 b229 NMOSWRAP
VG230 g230 0 2.3542664104807072
X230 36 g230 3 b230 NMOSWRAP
VG231 g231 0 2.4821842282335798
X231 36 g231 4 b231 NMOSWRAP
VG232 g232 0 1.4941808088811608
X232 36 g232 5 b232 NMOSWRAP
VG233 g233 0 1.2643730666244726
X233 36 g233 6 b233 NMOSWRAP
VG234 g234 0 2.1592739082023096
X234 36 g234 7 b234 NMOSWRAP
VG235 g235 0 1.6825783114321258
X235 36 g235 8 b235 NMOSWRAP
VG236 g236 0 2.8577574125269183
X236 36 g236 9 b236 NMOSWRAP
VG237 g237 0 2.1955179425312825
X237 36 g237 10 b237 NMOSWRAP
VG238 g238 0 1.6205257717778285
X238 36 g238 11 b238 NMOSWRAP
VG239 g239 0 2.6740192368094284
X239 36 g239 12 b239 NMOSWRAP
VG240 g240 0 1.6067833133614682
X240 37 g240 3 b240 NMOSWRAP
VG241 g241 0 1.1511971124998706
X241 37 g241 4 b241 NMOSWRAP
VG242 g242 0 2.5087337077486831
X242 37 g242 5 b242 NMOSWRAP
VG243 g243 0 1.8124693216855532
X243 37 g243 6 b243 NMOSWRAP
VG244 g244 0 1.3338309099096235
X244 37 g244 7 b244 NMOSWRAP
VG245 g245 0 2.3078983032327698
X245 37 g245 8 b245 NMOSWRAP
VG246 g246 0 2.9560914277472516
X246 37 g246 9 b246 NMOSWRAP
VG247 g247 0 1.3040705751775272
X247 37 g247 10 b247 NMOSWRAP
VG248 g248 0 2.5280485558366017
X248 37 g248 11 b248 NMOSWRAP
VG249 g249 0 2.4652542995041324
X249 37 g249 12 b249 NMOSWRAP
VG250 g250 0 1.0200895323991817
X250 38 g250 3 b250 NMOSWRAP
VG251 g251 0 2.6375308377577511
X251 38 g251 4 b251 NMOSWRAP
VG252 g252 0 1.7889125357021962
X252 38 g252 5 b252 NMOSWRAP
VG253 g253 0 1.0330081107444471
X253 38 g253 6 b253 NMOSWRAP
VG254 g254 0 1.9567728144661543
X254 38 g254 7 b254 NMOSWRAP
VG255 g255 0 1.4171536892879153
X255 38 g255 8 b255 NMOSWRAP
VG256 g256 0 1.1453794348276438
X256 38 g256 9 b256 NMOSWRAP
VG257 g257 0 0.9282858840767991
X257 38 g257 10 b257 NMOSWRAP
VG258 g258 0 1.1975229566163730
X258 38 g258 11 b258 NMOSWRAP
VG259 g259 0 1.7165743928769310
X259 38 g259 12 b259 NMOSWRAP
VG260 g260 0 2.1940764681648712
X260 39 g260 3 b260 NMOSWRAP
VG261 g261 0 0.9466031522770419
X261 39 g261 4 b261 NMOSWRAP
VG262 g262 0 2.3603938224846717
X262 39 g262 5 b262 NMOSWRAP
VG263 g263 0 0.9789258246676096
X263 39 g263 6 b263 NMOSWRAP
VG264 g264 0 1.1450979095448492
X264 39 g264 7 b264 NMOSWRAP
VG265 g265 0 2.3549735148541737
X265 39 g265 8 b265 NMOSWRAP
VG266 g266 0 2.7418432674236008
X266 39 g266 9 b266 NMOSWRAP
VG267 g267 0 2.9620613123469126
X267 39 g267 10 b267 NMOSWRAP
VG268 g268 0 2.2190406390777326
X268 39 g268 11 b268 NMOSWRAP
VG269 g269 0 1.8249067942643447
X269 39 g269 12 b269 NMOSWRAP
VG270 g270 0 0.9475219984912375
X270 40 g270 3 b270 NMOSWRAP
VG271 g271 0 2.0076392880688725
X271 40 g271 4 b271 NMOSWRAP
VG272 g272 0 1.1575880161694545
X272 40 g272 5 b272 NMOSWRAP
VG273 g273 0 1.9074046360602464
X273 40 g273 6 b273 NMOSWRAP
VG274 g274 0 2.1200928351023811
X274 40 g274 7 b274 NMOSWRAP
VG275 g275 0 2.6247281027758596
X275 40 g275 8 b275 NMOSWRAP
VG276 g276 0 1.4784388100763297
X276 40 g276 9 b276 NMOSWRAP
VG277 g277 0 2.9749397099693398
X277 40 g277 10 b277 NMOSWRAP
VG278 g278 0 2.9886380849275347
X278 40 g278 11 b278 NMOSWRAP
VG279 g279 0 2.6088393437395427
X279 40 g279 12 b279 NMOSWRAP
VG280 g280 0 2.3118432272066625
X280 41 g280 3 b280 NMOSWRAP
VG281 g281 0 2.4007570457181977
X281 41 g281 4 b281 NMOSWRAP
VG282 g282 0 2.7193548220604908
X282 41 g282 5 b282 NMOSWRAP
VG283 g283 0 2.8908978337778977
X283 41 g283 6 b283 NMOSWRAP
VG284 g284 0 2.6675915848444900
X284 41 g284 7 b284 NMOSWRAP
VG285 g285 0 2.1921119395024444
X285 41 g285 8 b285 NMOSWRAP
VG286 g286 0 0.9153713656074823
X286 41 g286 9 b286 NMOSWRAP
VG287 g287 0 2.1526156071656368
X287 41 g287 10 b287 NMOSWRAP
VG288 g288 0 1.5447312565174167
X288 41 g288 11 b288 NMOSWRAP
VG289 g289 0 1.1207519022546668
X289 41 g289 12 b289 NMOSWRAP
VG290 g290 0 2.7596239197758474
X290 42 g290 3 b290 NMOSWRAP
VG291 g291 0 2.6060035827150285
X291 42 g291 4 b291 NMOSWRAP
VG292 g292 0 1.9349364536688749
X292 42 g292 5 b292 NMOSWRAP
VG293 g293 0 1.7927608263455381
X293 42 g293 6 b293 NMOSWRAP
VG294 g294 0 1.8509278982860327
X294 42 g294 7 b294 NMOSWRAP
VG295 g295 0 1.3366200443687670
X295 42 g295 8 b295 NMOSWRAP
VG296 g296 0 1.6559353270495816
X296 42 g296 9 b296 NMOSWRAP
VG297 g297 0 1.7325072293858175
X297 42 g297 10 b297 NMOSWRAP
VG298 g298 0 0.7838763020588326
X298 42 g298 11 b298 NMOSWRAP
VG299 g299 0 2.7590382369271103
X299 42 g299 12 b299 NMOSWRAP
VG300 g300 0 0.8155859651569014
X300 43 g300 3 b300 NMOSWRAP
VG301 g301 0 1.5890089890263839
X301 43 g301 4 b301 NMOSWRAP
VG302 g302 0 0.9657149580587374
X302 43 g302 5 b302 NMOSWRAP
VG303 g303 0 1.1931697207875867
X303 43 g303 6 b303 NMOSWRAP
VG304 g304 0 2.8704463778935723
X304 43 g304 7 b304 NMOSWRAP
VG305 g305 0 1.5853601362527669
X305 43 g305 8 b305 NMOSWRAP
VG306 g306 0 2.3902518040983232
X306 43 g306 9 b306 NMOSWRAP
VG307 g307 0 1.0338602444152984
X307 43 g307 10 b307 NMOSWRAP
VG308 g308 0 1.3153865738412209
X308 43 g308 11 b308 NMOSWRAP
VG309 g309 0 2.7327794185227710
X309 43 g309 12 b309 NMOSWRAP
VG310 g310 0 2.7824163386002847
X310 44 g310 3 b310 NMOSWRAP
VG311 g311 0 1.3971793309857481
X311 44 g311 4 b311 NMOSWRAP
VG312 g312 0 2.9260045459026665
X312 44 g312 5 b312 NMOSWRAP
VG313 g313 0 2.2532235051566798
X313 44 g313 6 b313 NMOSWRAP
VG314 g314 0 1.8817652404522347
X314 44 g314 7 b314 NMOSWRAP
VG315 g315 0 1.6005054194592498
X315 44 g315 8 b315 NMOSWRAP
VG316 g316 0 1.5090786621670311
X316 44 g316 9 b316 NMOSWRAP
VG317 g317 0 2.8920240864367526
X317 44 g317 10 b317 NMOSWRAP
VG318 g318 0 2.3100011143257513
X318 44 g318 11 b318 NMOSWRAP
VG319 g319 0 1.9517288251650089
X319 44 g319 12 b319 NMOSWRAP
VG320 g320 0 0.8478518203566242
X320 45 g320 3 b320 NMOSWRAP
VG321 g321 0 1.3069894701507163
X321 45 g321 4 b321 NMOSWRAP
VG322 g322 0 2.8721341260012188
X322 45 g322 5 b322 NMOSWRAP
VG323 g323 0 2.0029353740473201
X323 45 g323 6 b323 NMOSWRAP
VG324 g324 0 1.5544160227992720
X324 45 g324 7 b324 NMOSWRAP
VG325 g325 0 0.7712633418102735
X325 45 g325 8 b325 NMOSWRAP
VG326 g326 0 1.3204836012560768
X326 45 g326 9 b326 NMOSWRAP
VG327 g327 0 1.3220100528387078
X327 45 g327 10 b327 NMOSWRAP
VG328 g328 0 1.1340424335765587
X328 45 g328 11 b328 NMOSWRAP
VG329 g329 0 1.5262049092736802
X329 45 g329 12 b329 NMOSWRAP
VG330 g330 0 1.2059603655323787
X330 46 g330 3 b330 NMOSWRAP
VG331 g331 0 0.8915284654068923
X331 46 g331 4 b331 NMOSWRAP
VG332 g332 0 0.9704108907440818
X332 46 g332 5 b332 NMOSWRAP
VG333 g333 0 1.8676368802067591
X333 46 g333 6 b333 NMOSWRAP
VG334 g334 0 0.9067363284280022
X334 46 g334 7 b334 NMOSWRAP
VG335 g335 0 2.8540955175408489
X335 46 g335 8 b335 NMOSWRAP
VG336 g336 0 1.2137196791338132
X336 46 g336 9 b336 NMOSWRAP
VG337 g337 0 1.7944777874078548
X337 46 g337 10 b337 NMOSWRAP
VG338 g338 0 1.6830035784899331
X338 46 g338 11 b338 NMOSWRAP
VG339 g339 0 1.4055098664742101
X339 46 g339 12 b339 NMOSWRAP
VG340 g340 0 1.4779391583450994
X340 47 g340 3 b340 NMOSWRAP
VG341 g341 0 1.2260945626863144
X341 47 g341 4 b341 NMOSWRAP
VG342 g342 0 1.3806036474829471
X342 47 g342 5 b342 NMOSWRAP
VG343 g343 0 1.0134863303173267
X343 47 g343 6 b343 NMOSWRAP
VG344 g344 0 2.3008167182494743
X344 47 g344 7 b344 NMOSWRAP
VG345 g345 0 2.2001839260925289
X345 47 g345 8 b345 NMOSWRAP
VG346 g346 0 1.4509411575217155
X346 47 g346 9 b346 NMOSWRAP
VG347 g347 0 2.7306726513543680
X347 47 g347 10 b347 NMOSWRAP
VG348 g348 0 1.6193453814627619
X348 47 g348 11 b348 NMOSWRAP
VG349 g349 0 2.1249509257174539
X349 47 g349 12 b349 NMOSWRAP
VG350 g350 0 1.9271309838941892
X350 48 g350 3 b350 NMOSWRAP
VG351 g351 0 1.4813778081227924
X351 48 g351 4 b351 NMOSWRAP
VG352 g352 0 2.8420284518966161
X352 48 g352 5 b352 NMOSWRAP
VG353 g353 0 2.6584531702416836
X353 48 g353 6 b353 NMOSWRAP
VG354 g354 0 2.6425266330447927
X354 48 g354 7 b354 NMOSWRAP
VG355 g355 0 2.8971494322517373
X355 48 g355 8 b355 NMOSWRAP
VG356 g356 0 0.7555854591032171
X356 48 g356 9 b356 NMOSWRAP
VG357 g357 0 1.8572679755189108
X357 48 g357 10 b357 NMOSWRAP
VG358 g358 0 2.8603045178953583
X358 48 g358 11 b358 NMOSWRAP
VG359 g359 0 1.0524602096020628
X359 48 g359 12 b359 NMOSWRAP
VG360 g360 0 1.3012368114318820
X360 49 g360 3 b360 NMOSWRAP
VG361 g361 0 1.8863893212985674
X361 49 g361 4 b361 NMOSWRAP
VG362 g362 0 2.2764483970992360
X362 49 g362 5 b362 NMOSWRAP
VG363 g363 0 1.4987099046381358
X363 49 g363 6 b363 NMOSWRAP
VG364 g364 0 1.4393205110775162
X364 49 g364 7 b364 NMOSWRAP
VG365 g365 0 2.4955453002484851
X365 49 g365 8 b365 NMOSWRAP
VG366 g366 0 0.8239213610140071
X366 49 g366 9 b366 NMOSWRAP
VG367 g367 0 2.5180451906738903
X367 49 g367 10 b367 NMOSWRAP
VG368 g368 0 1.7142156332854710
X368 49 g368 11 b368 NMOSWRAP
VG369 g369 0 2.1652712786292607
X369 49 g369 12 b369 NMOSWRAP
VG370 g370 0 2.3373818060402991
X370 50 g370 3 b370 NMOSWRAP
VG371 g371 0 0.9715544161981897
X371 50 g371 4 b371 NMOSWRAP
VG372 g372 0 2.7836538709684948
X372 50 g372 5 b372 NMOSWRAP
VG373 g373 0 2.6002030543899282
X373 50 g373 6 b373 NMOSWRAP
VG374 g374 0 1.5946082338209371
X374 50 g374 7 b374 NMOSWRAP
VG375 g375 0 1.1882872391156831
X375 50 g375 8 b375 NMOSWRAP
VG376 g376 0 0.8913122356256387
X376 50 g376 9 b376 NMOSWRAP
VG377 g377 0 1.4443700838154832
X377 50 g377 10 b377 NMOSWRAP
VG378 g378 0 2.3546819113546258
X378 50 g378 11 b378 NMOSWRAP
VG379 g379 0 2.5796588614047593
X379 50 g379 12 b379 NMOSWRAP
VG380 g380 0 1.4848236777387889
X380 51 g380 3 b380 NMOSWRAP
VG381 g381 0 1.2456522448675973
X381 51 g381 4 b381 NMOSWRAP
VG382 g382 0 1.4866369132047168
X382 51 g382 5 b382 NMOSWRAP
VG383 g383 0 2.9198253816879340
X383 51 g383 6 b383 NMOSWRAP
VG384 g384 0 0.9662040753983195
X384 51 g384 7 b384 NMOSWRAP
VG385 g385 0 1.1149127571988626
X385 51 g385 8 b385 NMOSWRAP
VG386 g386 0 2.3120380176437108
X386 51 g386 9 b386 NMOSWRAP
VG387 g387 0 1.0644678728574726
X387 51 g387 10 b387 NMOSWRAP
VG388 g388 0 1.3499082584170379
X388 51 g388 11 b388 NMOSWRAP
VG389 g389 0 2.5571457130306730
X389 51 g389 12 b389 NMOSWRAP
VG390 g390 0 1.4263765136813240
X390 52 g390 3 b390 NMOSWRAP
VG391 g391 0 2.0932872349603233
X391 52 g391 4 b391 NMOSWRAP
VG392 g392 0 2.0388276474720528
X392 52 g392 5 b392 NMOSWRAP
VG393 g393 0 1.3472478110520054
X393 52 g393 6 b393 NMOSWRAP
VG394 g394 0 1.3096521500084182
X394 52 g394 7 b394 NMOSWRAP
VG395 g395 0 1.4017698539895367
X395 52 g395 8 b395 NMOSWRAP
VG396 g396 0 2.7208651629540705
X396 52 g396 9 b396 NMOSWRAP
VG397 g397 0 0.7922058302342209
X397 52 g397 10 b397 NMOSWRAP
VG398 g398 0 0.9561819272526815
X398 52 g398 11 b398 NMOSWRAP
VG399 g399 0 1.5177224080970673
X399 52 g399 12 b399 NMOSWRAP
VG400 g400 0 1.2456787240192146
X400 53 g400 3 b400 NMOSWRAP
VG401 g401 0 2.0164291475603706
X401 53 g401 4 b401 NMOSWRAP
VG402 g402 0 1.9637874627922349
X402 53 g402 5 b402 NMOSWRAP
VG403 g403 0 1.8645645063097329
X403 53 g403 6 b403 NMOSWRAP
VG404 g404 0 1.4266944075075467
X404 53 g404 7 b404 NMOSWRAP
VG405 g405 0 1.9007596320109572
X405 53 g405 8 b405 NMOSWRAP
VG406 g406 0 2.5190141626909952
X406 53 g406 9 b406 NMOSWRAP
VG407 g407 0 2.5781375583574802
X407 53 g407 10 b407 NMOSWRAP
VG408 g408 0 1.9488919968656548
X408 53 g408 11 b408 NMOSWRAP
VG409 g409 0 2.5642542324236635
X409 53 g409 12 b409 NMOSWRAP
VG410 g410 0 0.8271198291217017
X410 54 g410 3 b410 NMOSWRAP
VG411 g411 0 1.0966487720238973
X411 54 g411 4 b411 NMOSWRAP
VG412 g412 0 2.4334163122545207
X412 54 g412 5 b412 NMOSWRAP
VG413 g413 0 1.6159572687501367
X413 54 g413 6 b413 NMOSWRAP
VG414 g414 0 1.4652716029395232
X414 54 g414 7 b414 NMOSWRAP
VG415 g415 0 2.0370198291757182
X415 54 g415 8 b415 NMOSWRAP
VG416 g416 0 1.5879461590568529
X416 54 g416 9 b416 NMOSWRAP
VG417 g417 0 2.7964422974807897
X417 54 g417 10 b417 NMOSWRAP
VG418 g418 0 1.6206852563016785
X418 54 g418 11 b418 NMOSWRAP
VG419 g419 0 2.6315606896888681
X419 54 g419 12 b419 NMOSWRAP
VG420 g420 0 2.1039683702119971
X420 55 g420 3 b420 NMOSWRAP
VG421 g421 0 2.8020422492451731
X421 55 g421 4 b421 NMOSWRAP
VG422 g422 0 1.8391205422980190
X422 55 g422 5 b422 NMOSWRAP
VG423 g423 0 2.9066566498402882
X423 55 g423 6 b423 NMOSWRAP
VG424 g424 0 2.0475967360191403
X424 55 g424 7 b424 NMOSWRAP
VG425 g425 0 0.8124246704686970
X425 55 g425 8 b425 NMOSWRAP
VG426 g426 0 2.4124594107397606
X426 55 g426 9 b426 NMOSWRAP
VG427 g427 0 2.6881517923102445
X427 55 g427 10 b427 NMOSWRAP
VG428 g428 0 0.9717375211577644
X428 55 g428 11 b428 NMOSWRAP
VG429 g429 0 2.9177468419002892
X429 55 g429 12 b429 NMOSWRAP
VG430 g430 0 2.0177085812286837
X430 56 g430 3 b430 NMOSWRAP
VG431 g431 0 2.4165792996098672
X431 56 g431 4 b431 NMOSWRAP
VG432 g432 0 1.2540029655285800
X432 56 g432 5 b432 NMOSWRAP
VG433 g433 0 2.8676606152968107
X433 56 g433 6 b433 NMOSWRAP
VG434 g434 0 2.1974890334157133
X434 56 g434 7 b434 NMOSWRAP
VG435 g435 0 1.9724669353492637
X435 56 g435 8 b435 NMOSWRAP
VG436 g436 0 2.9131279436452644
X436 56 g436 9 b436 NMOSWRAP
VG437 g437 0 2.0031796484999815
X437 56 g437 10 b437 NMOSWRAP
VG438 g438 0 1.9462538818774546
X438 56 g438 11 b438 NMOSWRAP
VG439 g439 0 0.8507256646193060
X439 56 g439 12 b439 NMOSWRAP
VG440 g440 0 1.9793751824196553
X440 57 g440 3 b440 NMOSWRAP
VG441 g441 0 2.4248120009889953
X441 57 g441 4 b441 NMOSWRAP
VG442 g442 0 1.5789072675720277
X442 57 g442 5 b442 NMOSWRAP
VG443 g443 0 2.2784835305577467
X443 57 g443 6 b443 NMOSWRAP
VG444 g444 0 2.0192425767389235
X444 57 g444 7 b444 NMOSWRAP
VG445 g445 0 1.2179437868618121
X445 57 g445 8 b445 NMOSWRAP
VG446 g446 0 1.9803313270235450
X446 57 g446 9 b446 NMOSWRAP
VG447 g447 0 1.8209746669783229
X447 57 g447 10 b447 NMOSWRAP
VG448 g448 0 1.5098691465888532
X448 57 g448 11 b448 NMOSWRAP
VG449 g449 0 2.2409292014284827
X449 57 g449 12 b449 NMOSWRAP
VG450 g450 0 0.8875959793349940
X450 58 g450 3 b450 NMOSWRAP
VG451 g451 0 1.5887357076432611
X451 58 g451 4 b451 NMOSWRAP
VG452 g452 0 1.7267460304922984
X452 58 g452 5 b452 NMOSWRAP
VG453 g453 0 2.9412021482786415
X453 58 g453 6 b453 NMOSWRAP
VG454 g454 0 2.3209485477832947
X454 58 g454 7 b454 NMOSWRAP
VG455 g455 0 2.1580243952912483
X455 58 g455 8 b455 NMOSWRAP
VG456 g456 0 1.1008751530372822
X456 58 g456 9 b456 NMOSWRAP
VG457 g457 0 1.7289579593789963
X457 58 g457 10 b457 NMOSWRAP
VG458 g458 0 1.5852789725123471
X458 58 g458 11 b458 NMOSWRAP
VG459 g459 0 2.8658944879153800
X459 58 g459 12 b459 NMOSWRAP
VG460 g460 0 1.7688396701596729
X460 59 g460 3 b460 NMOSWRAP
VG461 g461 0 2.6739749705755060
X461 59 g461 4 b461 NMOSWRAP
VG462 g462 0 2.2206266656792639
X462 59 g462 5 b462 NMOSWRAP
VG463 g463 0 2.7283956496885975
X463 59 g463 6 b463 NMOSWRAP
VG464 g464 0 0.7575047507979238
X464 59 g464 7 b464 NMOSWRAP
VG465 g465 0 2.8307735316226155
X465 59 g465 8 b465 NMOSWRAP
VG466 g466 0 2.8904109471295714
X466 59 g466 9 b466 NMOSWRAP
VG467 g467 0 1.0986049125600421
X467 59 g467 10 b467 NMOSWRAP
VG468 g468 0 0.8978490211327089
X468 59 g468 11 b468 NMOSWRAP
VG469 g469 0 1.4638875543548564
X469 59 g469 12 b469 NMOSWRAP
VG470 g470 0 2.0674997622245517
X470 60 g470 3 b470 NMOSWRAP
VG471 g471 0 1.9292955263509883
X471 60 g471 4 b471 NMOSWRAP
VG472 g472 0 1.7290258921766373
X472 60 g472 5 b472 NMOSWRAP
VG473 g473 0 2.8035235931569717
X473 60 g473 6 b473 NMOSWRAP
VG474 g474 0 2.0324474669832382
X474 60 g474 7 b474 NMOSWRAP
VG475 g475 0 2.8518076845621332
X475 60 g475 8 b475 NMOSWRAP
VG476 g476 0 2.0463472966261547
X476 60 g476 9 b476 NMOSWRAP
VG477 g477 0 1.1666554368364486
X477 60 g477 10 b477 NMOSWRAP
VG478 g478 0 2.9596770949950484
X478 60 g478 11 b478 NMOSWRAP
VG479 g479 0 2.9966323359249833
X479 60 g479 12 b479 NMOSWRAP
VG480 g480 0 1.7545532437504909
X480 61 g480 3 b480 NMOSWRAP
VG481 g481 0 2.4654687561811199
X481 61 g481 4 b481 NMOSWRAP
VG482 g482 0 2.1822676909153085
X482 61 g482 5 b482 NMOSWRAP
VG483 g483 0 1.1667989435544710
X483 61 g483 6 b483 NMOSWRAP
VG484 g484 0 2.0532044101535312
X484 61 g484 7 b484 NMOSWRAP
VG485 g485 0 2.2220443529199381
X485 61 g485 8 b485 NMOSWRAP
VG486 g486 0 2.0859158329401359
X486 61 g486 9 b486 NMOSWRAP
VG487 g487 0 1.9683224377353761
X487 61 g487 10 b487 NMOSWRAP
VG488 g488 0 2.0817279042055130
X488 61 g488 11 b488 NMOSWRAP
VG489 g489 0 2.3452301376605504
X489 61 g489 12 b489 NMOSWRAP
VG490 g490 0 2.4847004407379503
X490 62 g490 3 b490 NMOSWRAP
VG491 g491 0 0.9503629416699473
X491 62 g491 4 b491 NMOSWRAP
VG492 g492 0 2.8053648534298796
X492 62 g492 5 b492 NMOSWRAP
VG493 g493 0 1.7616562613799274
X493 62 g493 6 b493 NMOSWRAP
VG494 g494 0 2.3173975105751881
X494 62 g494 7 b494 NMOSWRAP
VG495 g495 0 1.6221878606251188
X495 62 g495 8 b495 NMOSWRAP
VG496 g496 0 0.8648785846982104
X496 62 g496 9 b496 NMOSWRAP
VG497 g497 0 2.2431928296433159
X497 62 g497 10 b497 NMOSWRAP
VG498 g498 0 1.5727362693349476
X498 62 g498 11 b498 NMOSWRAP
VG499 g499 0 1.9937549102957504
X499 62 g499 12 b499 NMOSWRAP
VG500 g500 0 1.3498271412538752
X500 63 g500 3 b500 NMOSWRAP
VG501 g501 0 1.2087211815117884
X501 63 g501 4 b501 NMOSWRAP
VG502 g502 0 1.4164611460781926
X502 63 g502 5 b502 NMOSWRAP
VG503 g503 0 2.6442021733319994
X503 63 g503 6 b503 NMOSWRAP
VG504 g504 0 2.8290341812663931
X504 63 g504 7 b504 NMOSWRAP
VG505 g505 0 2.9518130721006819
X505 63 g505 8 b505 NMOSWRAP
VG506 g506 0 1.6822446315740009
X506 63 g506 9 b506 NMOSWRAP
VG507 g507 0 2.4896697812179744
X507 63 g507 10 b507 NMOSWRAP
VG508 g508 0 1.1281195213285922
X508 63 g508 11 b508 NMOSWRAP
VG509 g509 0 2.4245757551018521
X509 63 g509 12 b509 NMOSWRAP
VG510 g510 0 1.7044642165488162
X510 64 g510 3 b510 NMOSWRAP
VG511 g511 0 2.6492072006299727
X511 64 g511 4 b511 NMOSWRAP
VG512 g512 0 1.1932955828843876
X512 64 g512 5 b512 NMOSWRAP
VG513 g513 0 2.5925599681326497
X513 64 g513 6 b513 NMOSWRAP
VG514 g514 0 0.9127319770054011
X514 64 g514 7 b514 NMOSWRAP
VG515 g515 0 2.6537423514423839
X515 64 g515 8 b515 NMOSWRAP
VG516 g516 0 1.7032101069861598
X516 64 g516 9 b516 NMOSWRAP
VG517 g517 0 1.0666680496882881
X517 64 g517 10 b517 NMOSWRAP
VG518 g518 0 1.4383135895176962
X518 64 g518 11 b518 NMOSWRAP
VG519 g519 0 2.3460643503386041
X519 64 g519 12 b519 NMOSWRAP
VG520 g520 0 1.7541411767710766
X520 65 g520 3 b520 NMOSWRAP
VG521 g521 0 1.2748448073507406
X521 65 g521 4 b521 NMOSWRAP
VG522 g522 0 1.2872223640120499
X522 65 g522 5 b522 NMOSWRAP
VG523 g523 0 2.3096398192566987
X523 65 g523 6 b523 NMOSWRAP
VG524 g524 0 2.2074813252622696
X524 65 g524 7 b524 NMOSWRAP
VG525 g525 0 0.8938314661799882
X525 65 g525 8 b525 NMOSWRAP
VG526 g526 0 2.5781648237001025
X526 65 g526 9 b526 NMOSWRAP
VG527 g527 0 1.0654144121266216
X527 65 g527 10 b527 NMOSWRAP
VG528 g528 0 1.2912695499260161
X528 65 g528 11 b528 NMOSWRAP
VG529 g529 0 0.7812836066655391
X529 65 g529 12 b529 NMOSWRAP
VG530 g530 0 1.8890733795135011
X530 66 g530 3 b530 NMOSWRAP
VG531 g531 0 2.6645971098648120
X531 66 g531 4 b531 NMOSWRAP
VG532 g532 0 2.8419084393128999
X532 66 g532 5 b532 NMOSWRAP
VG533 g533 0 1.7924469924971165
X533 66 g533 6 b533 NMOSWRAP
VG534 g534 0 0.9811858698459632
X534 66 g534 7 b534 NMOSWRAP
VG535 g535 0 1.8171865104481861
X535 66 g535 8 b535 NMOSWRAP
VG536 g536 0 1.4035311098919001
X536 66 g536 9 b536 NMOSWRAP
VG537 g537 0 1.4461438812110348
X537 66 g537 10 b537 NMOSWRAP
VG538 g538 0 1.2966579527338467
X538 66 g538 11 b538 NMOSWRAP
VG539 g539 0 2.8958059850547797
X539 66 g539 12 b539 NMOSWRAP
VG540 g540 0 1.6441732408674663
X540 67 g540 3 b540 NMOSWRAP
VG541 g541 0 0.7580402252964055
X541 67 g541 4 b541 NMOSWRAP
VG542 g542 0 1.8643398655324739
X542 67 g542 5 b542 NMOSWRAP
VG543 g543 0 2.3254449310824414
X543 67 g543 6 b543 NMOSWRAP
VG544 g544 0 2.5843582115284565
X544 67 g544 7 b544 NMOSWRAP
VG545 g545 0 2.4451203660196867
X545 67 g545 8 b545 NMOSWRAP
VG546 g546 0 2.3298650983869567
X546 67 g546 9 b546 NMOSWRAP
VG547 g547 0 1.1957151633362262
X547 67 g547 10 b547 NMOSWRAP
VG548 g548 0 1.5377370992087152
X548 67 g548 11 b548 NMOSWRAP
VG549 g549 0 1.7838121410553769
X549 67 g549 12 b549 NMOSWRAP
VG550 g550 0 1.0581652840952023
X550 68 g550 3 b550 NMOSWRAP
VG551 g551 0 1.7115993061903976
X551 68 g551 4 b551 NMOSWRAP
VG552 g552 0 0.9783483522286606
X552 68 g552 5 b552 NMOSWRAP
VG553 g553 0 0.9463251342137315
X553 68 g553 6 b553 NMOSWRAP
VG554 g554 0 2.6314178873203566
X554 68 g554 7 b554 NMOSWRAP
VG555 g555 0 1.1301320064403630
X555 68 g555 8 b555 NMOSWRAP
VG556 g556 0 1.8139539272030072
X556 68 g556 9 b556 NMOSWRAP
VG557 g557 0 2.1560528958620817
X557 68 g557 10 b557 NMOSWRAP
VG558 g558 0 2.8626799889335590
X558 68 g558 11 b558 NMOSWRAP
VG559 g559 0 1.4392272573803100
X559 68 g559 12 b559 NMOSWRAP
VG560 g560 0 1.1575232587100557
X560 69 g560 3 b560 NMOSWRAP
VG561 g561 0 2.7196980222590552
X561 69 g561 4 b561 NMOSWRAP
VG562 g562 0 1.4330680449353821
X562 69 g562 5 b562 NMOSWRAP
VG563 g563 0 1.3747194133218523
X563 69 g563 6 b563 NMOSWRAP
VG564 g564 0 1.0877877668097669
X564 69 g564 7 b564 NMOSWRAP
VG565 g565 0 1.7505341000450840
X565 69 g565 8 b565 NMOSWRAP
VG566 g566 0 1.2708181332667898
X566 69 g566 9 b566 NMOSWRAP
VG567 g567 0 1.5574385926760963
X567 69 g567 10 b567 NMOSWRAP
VG568 g568 0 1.5007047977441821
X568 69 g568 11 b568 NMOSWRAP
VG569 g569 0 2.1559970320113444
X569 69 g569 12 b569 NMOSWRAP
VG570 g570 0 1.7528299434452885
X570 70 g570 3 b570 NMOSWRAP
VG571 g571 0 2.2753727478278818
X571 70 g571 4 b571 NMOSWRAP
VG572 g572 0 1.4269279552742145
X572 70 g572 5 b572 NMOSWRAP
VG573 g573 0 1.4753590411498960
X573 70 g573 6 b573 NMOSWRAP
VG574 g574 0 2.9961289428864788
X574 70 g574 7 b574 NMOSWRAP
VG575 g575 0 1.2861162925932279
X575 70 g575 8 b575 NMOSWRAP
VG576 g576 0 2.4664383272853816
X576 70 g576 9 b576 NMOSWRAP
VG577 g577 0 2.3240700368700669
X577 70 g577 10 b577 NMOSWRAP
VG578 g578 0 2.2076414650945022
X578 70 g578 11 b578 NMOSWRAP
VG579 g579 0 1.0235135983162973
X579 70 g579 12 b579 NMOSWRAP
VG580 g580 0 0.7625377138495480
X580 71 g580 3 b580 NMOSWRAP
VG581 g581 0 2.4274948312457676
X581 71 g581 4 b581 NMOSWRAP
VG582 g582 0 0.9368141225078261
X582 71 g582 5 b582 NMOSWRAP
VG583 g583 0 1.2961180207730523
X583 71 g583 6 b583 NMOSWRAP
VG584 g584 0 2.9757621714651177
X584 71 g584 7 b584 NMOSWRAP
VG585 g585 0 2.9237568946186405
X585 71 g585 8 b585 NMOSWRAP
VG586 g586 0 2.8229806870907099
X586 71 g586 9 b586 NMOSWRAP
VG587 g587 0 2.0623450787277573
X587 71 g587 10 b587 NMOSWRAP
VG588 g588 0 1.7765220825860475
X588 71 g588 11 b588 NMOSWRAP
VG589 g589 0 1.7902596045263663
X589 71 g589 12 b589 NMOSWRAP
VG590 g590 0 1.5144130835622158
X590 72 g590 3 b590 NMOSWRAP
VG591 g591 0 2.9265449298713762
X591 72 g591 4 b591 NMOSWRAP
VG592 g592 0 2.5859539842880963
X592 72 g592 5 b592 NMOSWRAP
VG593 g593 0 2.9818317841747777
X593 72 g593 6 b593 NMOSWRAP
VG594 g594 0 1.4269838551117253
X594 72 g594 7 b594 NMOSWRAP
VG595 g595 0 2.0546641320520860
X595 72 g595 8 b595 NMOSWRAP
VG596 g596 0 2.2846526876005520
X596 72 g596 9 b596 NMOSWRAP
VG597 g597 0 1.6131655977221808
X597 72 g597 10 b597 NMOSWRAP
VG598 g598 0 2.0644005002789250
X598 72 g598 11 b598 NMOSWRAP
VG599 g599 0 1.1921637411879855
X599 72 g599 12 b599 NMOSWRAP
VG600 g600 0 1.4562034592307929
X600 73 g600 3 b600 NMOSWRAP
VG601 g601 0 1.0536303721852995
X601 73 g601 4 b601 NMOSWRAP
VG602 g602 0 2.1962520958619853
X602 73 g602 5 b602 NMOSWRAP
VG603 g603 0 1.5018217045751032
X603 73 g603 6 b603 NMOSWRAP
VG604 g604 0 1.7058815302562111
X604 73 g604 7 b604 NMOSWRAP
VG605 g605 0 1.6062741276505310
X605 73 g605 8 b605 NMOSWRAP
VG606 g606 0 0.8686871198938354
X606 73 g606 9 b606 NMOSWRAP
VG607 g607 0 2.7656711642694276
X607 73 g607 10 b607 NMOSWRAP
VG608 g608 0 2.3868180152849030
X608 73 g608 11 b608 NMOSWRAP
VG609 g609 0 1.4790746899599128
X609 73 g609 12 b609 NMOSWRAP
VG610 g610 0 2.7720734687142099
X610 74 g610 3 b610 NMOSWRAP
VG611 g611 0 2.2701522493042119
X611 74 g611 4 b611 NMOSWRAP
VG612 g612 0 2.9812600363108226
X612 74 g612 5 b612 NMOSWRAP
VG613 g613 0 1.7922291641369061
X613 74 g613 6 b613 NMOSWRAP
VG614 g614 0 0.9966177175062342
X614 74 g614 7 b614 NMOSWRAP
VG615 g615 0 1.0235966475752858
X615 74 g615 8 b615 NMOSWRAP
VG616 g616 0 2.4295611160282995
X616 74 g616 9 b616 NMOSWRAP
VG617 g617 0 2.0521823350586805
X617 74 g617 10 b617 NMOSWRAP
VG618 g618 0 1.2378213512421530
X618 74 g618 11 b618 NMOSWRAP
VG619 g619 0 1.9820907716187417
X619 74 g619 12 b619 NMOSWRAP
VG620 g620 0 1.9420587271246572
X620 75 g620 3 b620 NMOSWRAP
VG621 g621 0 2.6799967505342721
X621 75 g621 4 b621 NMOSWRAP
VG622 g622 0 0.8694215497036721
X622 75 g622 5 b622 NMOSWRAP
VG623 g623 0 1.0043655455763436
X623 75 g623 6 b623 NMOSWRAP
VG624 g624 0 1.7458524658043058
X624 75 g624 7 b624 NMOSWRAP
VG625 g625 0 1.0636884598263618
X625 75 g625 8 b625 NMOSWRAP
VG626 g626 0 2.9746704987234698
X626 75 g626 9 b626 NMOSWRAP
VG627 g627 0 1.1960682931929585
X627 75 g627 10 b627 NMOSWRAP
VG628 g628 0 2.1441742262713226
X628 75 g628 11 b628 NMOSWRAP
VG629 g629 0 1.7482282140131786
X629 75 g629 12 b629 NMOSWRAP
VG630 g630 0 2.5087673034809468
X630 76 g630 3 b630 NMOSWRAP
VG631 g631 0 0.8684165291290538
X631 76 g631 4 b631 NMOSWRAP
VG632 g632 0 1.4798888940377553
X632 76 g632 5 b632 NMOSWRAP
VG633 g633 0 1.8069883861689786
X633 76 g633 6 b633 NMOSWRAP
VG634 g634 0 1.0056763305648335
X634 76 g634 7 b634 NMOSWRAP
VG635 g635 0 2.1926489462182701
X635 76 g635 8 b635 NMOSWRAP
VG636 g636 0 1.9519829775254554
X636 76 g636 9 b636 NMOSWRAP
VG637 g637 0 2.6103193732866137
X637 76 g637 10 b637 NMOSWRAP
VG638 g638 0 1.7451413748275928
X638 76 g638 11 b638 NMOSWRAP
VG639 g639 0 1.4137968069571636
X639 76 g639 12 b639 NMOSWRAP
.options TEMP = 27C
.options TNOM = 27C
.options itl1=40 itl2=40 itl4=6 itl5=60
.options gmin=1e-8 reltol=5e-3 abstol=1e-8 vntol=1e-5
.options rshunt=1e9
.op
.end
