.title scikit_digits_dense_io_hinge
.include "/home/ma-lab/Desktop/pyclln-final/device_model/nmos_lvl1_ald1106.lib"
.options klu
VMINUS 1 0 0.0000000000000000
VPLUS  2 0 0.4500000000000000
VIN0 13 0 0
VIN1 14 0 0
VIN2 15 0 0
VIN3 16 0 0
VIN4 17 0 0
VIN5 18 0 0
VIN6 19 0 0
VIN7 20 0 0
VIN8 21 0 0
VIN9 22 0 0
VIN10 23 0 0
VIN11 24 0 0
VIN12 25 0 0
VIN13 26 0 0
VIN14 27 0 0
VIN15 28 0 0
VIN16 29 0 0
VIN17 30 0 0
VIN18 31 0 0
VIN19 32 0 0
VIN20 33 0 0
VIN21 34 0 0
VIN22 35 0 0
VIN23 36 0 0
VIN24 37 0 0
VIN25 38 0 0
VIN26 39 0 0
VIN27 40 0 0
VIN28 41 0 0
VIN29 42 0 0
VIN30 43 0 0
VIN31 44 0 0
VIN32 45 0 0
VIN33 46 0 0
VIN34 47 0 0
VIN35 48 0 0
VIN36 49 0 0
VIN37 50 0 0
VIN38 51 0 0
VIN39 52 0 0
VIN40 53 0 0
VIN41 54 0 0
VIN42 55 0 0
VIN43 56 0 0
VIN44 57 0 0
VIN45 58 0 0
VIN46 59 0 0
VIN47 60 0 0
VIN48 61 0 0
VIN49 62 0 0
VIN50 63 0 0
VIN51 64 0 0
VIN52 65 0 0
VIN53 66 0 0
VIN54 67 0 0
VIN55 68 0 0
VIN56 69 0 0
VIN57 70 0 0
VIN58 71 0 0
VIN59 72 0 0
VIN60 73 0 0
VIN61 74 0 0
VIN62 75 0 0
VIN63 76 0 0
RS1 3 77 1e+12
RS2 4 78 1e+12
RS3 5 79 1e+12
RS4 6 80 1e+12
RS5 7 81 1e+12
RS6 8 82 1e+12
RS7 9 83 1e+12
RS8 10 84 1e+12
RS9 11 85 1e+12
RS10 12 86 1e+12
VOUT0 77 0 0
VOUT1 78 0 0
VOUT2 79 0 0
VOUT3 80 0 0
VOUT4 81 0 0
VOUT5 82 0 0
VOUT6 83 0 0
VOUT7 84 0 0
VOUT8 85 0 0
VOUT9 86 0 0
VG0 g0 0 1.8720337598183119
RB0 b0 3 10
X0 13 g0 3 b0 NMOSWRAP
VG1 g1 0 2.2879734159310487
RB1 b1 4 10
X1 13 g1 4 b1 NMOSWRAP
VG2 g2 0 2.0069084401791097
RB2 b2 5 10
X2 13 g2 5 b2 NMOSWRAP
VG3 g3 0 1.8622079574922421
RB3 b3 6 10
X3 13 g3 6 b3 NMOSWRAP
VG4 g4 0 1.5591369983472618
RB4 b4 7 10
X4 13 g4 7 b4 NMOSWRAP
VG5 g5 0 2.1147352826666403
RB5 b5 8 10
X5 13 g5 8 b5 NMOSWRAP
VG6 g6 0 1.5939680281567312
RB6 b6 9 10
X6 13 g6 9 b6 NMOSWRAP
VG7 g7 0 2.7294325019551993
RB7 b7 10 10
X7 13 g7 10 b7 NMOSWRAP
VG8 g8 0 2.9091569012525733
RB8 b8 11 10
X8 13 g8 11 b8 NMOSWRAP
VG9 g9 0 1.4586037970644443
RB9 b9 12 10
X9 13 g9 12 b9 NMOSWRAP
VG10 g10 0 2.4793125952066615
RB10 b10 3 10
X10 14 g10 3 b10 NMOSWRAP
VG11 g11 0 1.8222372993822611
RB11 b11 4 10
X11 14 g11 4 b11 NMOSWRAP
VG12 g12 0 1.9201114027348307
RB12 b12 5 10
X12 14 g12 5 b12 NMOSWRAP
VG13 g13 0 2.8139915957316526
RB13 b13 6 10
X13 14 g13 6 b13 NMOSWRAP
VG14 g14 0 0.6775901454947173
RB14 b14 7 10
X14 14 g14 7 b14 NMOSWRAP
VG15 g15 0 0.7178232492538518
RB15 b15 8 10
X15 14 g15 8 b15 NMOSWRAP
VG16 g16 0 0.5505459936008144
RB16 b16 9 10
X16 14 g16 9 b16 NMOSWRAP
VG17 g17 0 2.5815496138698451
RB17 b17 10 10
X17 14 g17 10 b17 NMOSWRAP
VG18 g18 0 2.4453918773746262
RB18 b18 11 10
X18 14 g18 11 b18 NMOSWRAP
VG19 g19 0 2.6750303706170477
RB19 b19 12 10
X19 14 g19 12 b19 NMOSWRAP
VG20 g20 0 2.9465458555819102
RB20 b20 3 10
X20 15 g20 3 b20 NMOSWRAP
VG21 g21 0 2.4978964105418089
RB21 b21 4 10
X21 15 g21 4 b21 NMOSWRAP
VG22 g22 0 1.6536984056323296
RB22 b22 5 10
X22 15 g22 5 b22 NMOSWRAP
VG23 g23 0 2.4513229407161385
RB23 b23 6 10
X23 15 g23 6 b23 NMOSWRAP
VG24 g24 0 0.7956860646723330
RB24 b24 7 10
X24 15 g24 7 b24 NMOSWRAP
VG25 g25 0 2.0998025533188098
RB25 b25 8 10
X25 15 g25 8 b25 NMOSWRAP
VG26 g26 0 0.8583832185226160
RB26 b26 9 10
X26 15 g26 9 b26 NMOSWRAP
VG27 g27 0 2.8616722926239597
RB27 b27 10 10
X27 15 g27 10 b27 NMOSWRAP
VG28 g28 0 1.8046208043751792
RB28 b28 11 10
X28 15 g28 11 b28 NMOSWRAP
VG29 g29 0 1.5366548499763089
RB29 b29 12 10
X29 15 g29 12 b29 NMOSWRAP
VG30 g30 0 1.1613890302615675
RB30 b30 3 10
X30 16 g30 3 b30 NMOSWRAP
VG31 g31 0 2.4355842235855416
RB31 b31 4 10
X31 16 g31 4 b31 NMOSWRAP
VG32 g32 0 1.6403758305413714
RB32 b32 5 10
X32 16 g32 5 b32 NMOSWRAP
VG33 g33 0 1.9210848721716212
RB33 b33 6 10
X33 16 g33 6 b33 NMOSWRAP
VG34 g34 0 0.5469745010908879
RB34 b34 7 10
X34 16 g34 7 b34 NMOSWRAP
VG35 g35 0 2.0440887426896928
RB35 b35 8 10
X35 16 g35 8 b35 NMOSWRAP
VG36 g36 0 2.0302393068060534
RB36 b36 9 10
X36 16 g36 9 b36 NMOSWRAP
VG37 g37 0 2.0423349921868921
RB37 b37 10 10
X37 16 g37 10 b37 NMOSWRAP
VG38 g38 0 2.8593701962865605
RB38 b38 11 10
X38 16 g38 11 b38 NMOSWRAP
VG39 g39 0 2.2045507477587085
RB39 b39 12 10
X39 16 g39 12 b39 NMOSWRAP
VG40 g40 0 1.3987697514344650
RB40 b40 3 10
X40 17 g40 3 b40 NMOSWRAP
VG41 g41 0 1.5925798844983536
RB41 b41 4 10
X41 17 g41 4 b41 NMOSWRAP
VG42 g42 0 2.2440779898181624
RB42 b42 5 10
X42 17 g42 5 b42 NMOSWRAP
VG43 g43 0 0.6505636790731746
RB43 b43 6 10
X43 17 g43 6 b43 NMOSWRAP
VG44 g44 0 2.1669167886141691
RB44 b44 7 10
X44 17 g44 7 b44 NMOSWRAP
VG45 g45 0 2.1765946740453987
RB45 b45 8 10
X45 17 g45 8 b45 NMOSWRAP
VG46 g46 0 1.0259564026846022
RB46 b46 9 10
X46 17 g46 9 b46 NMOSWRAP
VG47 g47 0 0.8223157441371333
RB47 b47 10 10
X47 17 g47 10 b47 NMOSWRAP
VG48 g48 0 1.2885708773104596
RB48 b48 11 10
X48 17 g48 11 b48 NMOSWRAP
VG49 g49 0 1.4092769273565566
RB49 b49 12 10
X49 17 g49 12 b49 NMOSWRAP
VG50 g50 0 1.9254919260446992
RB50 b50 3 10
X50 18 g50 3 b50 NMOSWRAP
VG51 g51 0 1.5965037836558009
RB51 b51 4 10
X51 18 g51 4 b51 NMOSWRAP
VG52 g52 0 2.9709345951480657
RB52 b52 5 10
X52 18 g52 5 b52 NMOSWRAP
VG53 g53 0 0.7551120268700702
RB53 b53 6 10
X53 18 g53 6 b53 NMOSWRAP
VG54 g54 0 1.0221918902370868
RB54 b54 7 10
X54 18 g54 7 b54 NMOSWRAP
VG55 g55 0 0.9032737947124907
RB55 b55 8 10
X55 18 g55 8 b55 NMOSWRAP
VG56 g56 0 2.1327708136634960
RB56 b56 9 10
X56 18 g56 9 b56 NMOSWRAP
VG57 g57 0 1.1332290063494552
RB57 b57 10 10
X57 18 g57 10 b57 NMOSWRAP
VG58 g58 0 1.6657769321407656
RB58 b58 11 10
X58 18 g58 11 b58 NMOSWRAP
VG59 g59 0 1.1110639800040070
RB59 b59 12 10
X59 18 g59 12 b59 NMOSWRAP
VG60 g60 0 0.8974239591137994
RB60 b60 3 10
X60 19 g60 3 b60 NMOSWRAP
VG61 g61 0 0.7759378529107628
RB61 b61 4 10
X61 19 g61 4 b61 NMOSWRAP
VG62 g62 0 2.1408239736631836
RB62 b62 5 10
X62 19 g62 5 b62 NMOSWRAP
VG63 g63 0 0.8454573783715345
RB63 b63 6 10
X63 19 g63 6 b63 NMOSWRAP
VG64 g64 0 0.9914559042001337
RB64 b64 7 10
X64 19 g64 7 b64 NMOSWRAP
VG65 g65 0 1.4218129266524102
RB65 b65 8 10
X65 19 g65 8 b65 NMOSWRAP
VG66 g66 0 2.5524830746198379
RB66 b66 9 10
X66 19 g66 9 b66 NMOSWRAP
VG67 g67 0 0.7427531894826531
RB67 b67 10 10
X67 19 g67 10 b67 NMOSWRAP
VG68 g68 0 2.5948622687470095
RB68 b68 11 10
X68 19 g68 11 b68 NMOSWRAP
VG69 g69 0 0.7402460197349077
RB69 b69 12 10
X69 19 g69 12 b69 NMOSWRAP
VG70 g70 0 2.9411486625334895
RB70 b70 3 10
X70 20 g70 3 b70 NMOSWRAP
VG71 g71 0 1.6716280041192539
RB71 b71 4 10
X71 20 g71 4 b71 NMOSWRAP
VG72 g72 0 2.9419027204758428
RB72 b72 5 10
X72 20 g72 5 b72 NMOSWRAP
VG73 g73 0 2.0121137993626150
RB73 b73 6 10
X73 20 g73 6 b73 NMOSWRAP
VG74 g74 0 2.3481589484957541
RB74 b74 7 10
X74 20 g74 7 b74 NMOSWRAP
VG75 g75 0 0.5979694806358017
RB75 b75 8 10
X75 20 g75 8 b75 NMOSWRAP
VG76 g76 0 1.2070174064410240
RB76 b76 9 10
X76 20 g76 9 b76 NMOSWRAP
VG77 g77 0 0.8004914030329222
RB77 b77 10 10
X77 20 g77 10 b77 NMOSWRAP
VG78 g78 0 1.2403504938053622
RB78 b78 11 10
X78 20 g78 11 b78 NMOSWRAP
VG79 g79 0 0.7968192973856101
RB79 b79 12 10
X79 20 g79 12 b79 NMOSWRAP
VG80 g80 0 1.2949579484849401
RB80 b80 3 10
X80 21 g80 3 b80 NMOSWRAP
VG81 g81 0 1.5356574862866750
RB81 b81 4 10
X81 21 g81 4 b81 NMOSWRAP
VG82 g82 0 0.6603687408719610
RB82 b82 5 10
X82 21 g82 5 b82 NMOSWRAP
VG83 g83 0 2.2311802984250497
RB83 b83 6 10
X83 21 g83 6 b83 NMOSWRAP
VG84 g84 0 1.9165036355164378
RB84 b84 7 10
X84 21 g84 7 b84 NMOSWRAP
VG85 g85 0 1.1634737273486135
RB85 b85 8 10
X85 21 g85 8 b85 NMOSWRAP
VG86 g86 0 1.8081201336667492
RB86 b86 9 10
X86 21 g86 9 b86 NMOSWRAP
VG87 g87 0 0.7348512768961042
RB87 b87 10 10
X87 21 g87 10 b87 NMOSWRAP
VG88 g88 0 1.9398662388904482
RB88 b88 11 10
X88 21 g88 11 b88 NMOSWRAP
VG89 g89 0 2.8232404939405353
RB89 b89 12 10
X89 21 g89 12 b89 NMOSWRAP
VG90 g90 0 1.2964223811283091
RB90 b90 3 10
X90 22 g90 3 b90 NMOSWRAP
VG91 g91 0 2.1685259499092044
RB91 b91 4 10
X91 22 g91 4 b91 NMOSWRAP
VG92 g92 0 0.8294946560109804
RB92 b92 5 10
X92 22 g92 5 b92 NMOSWRAP
VG93 g93 0 2.2908180102964137
RB93 b93 6 10
X93 22 g93 6 b93 NMOSWRAP
VG94 g94 0 1.2235152323680027
RB94 b94 7 10
X94 22 g94 7 b94 NMOSWRAP
VG95 g95 0 0.9579784050177921
RB95 b95 8 10
X95 22 g95 8 b95 NMOSWRAP
VG96 g96 0 1.9662823370252078
RB96 b96 9 10
X96 22 g96 9 b96 NMOSWRAP
VG97 g97 0 0.5502688654687339
RB97 b97 10 10
X97 22 g97 10 b97 NMOSWRAP
VG98 g98 0 2.5723500730434079
RB98 b98 11 10
X98 22 g98 11 b98 NMOSWRAP
VG99 g99 0 0.5117386904813677
RB99 b99 12 10
X99 22 g99 12 b99 NMOSWRAP
VG100 g100 0 2.1945413419905755
RB100 b100 3 10
X100 23 g100 3 b100 NMOSWRAP
VG101 g101 0 1.1750199329804121
RB101 b101 4 10
X101 23 g101 4 b101 NMOSWRAP
VG102 g102 0 2.3379850553064871
RB102 b102 5 10
X102 23 g102 5 b102 NMOSWRAP
VG103 g103 0 2.9054713627935955
RB103 b103 6 10
X103 23 g103 6 b103 NMOSWRAP
VG104 g104 0 1.1218828587998950
RB104 b104 7 10
X104 23 g104 7 b104 NMOSWRAP
VG105 g105 0 1.9403933360445922
RB105 b105 8 10
X105 23 g105 8 b105 NMOSWRAP
VG106 g106 0 1.9801048281795977
RB106 b106 9 10
X106 23 g106 9 b106 NMOSWRAP
VG107 g107 0 1.9306297644771835
RB107 b107 10 10
X107 23 g107 10 b107 NMOSWRAP
VG108 g108 0 1.0577040816015457
RB108 b108 11 10
X108 23 g108 11 b108 NMOSWRAP
VG109 g109 0 2.8818725287924627
RB109 b109 12 10
X109 23 g109 12 b109 NMOSWRAP
VG110 g110 0 1.6178134465440683
RB110 b110 3 10
X110 24 g110 3 b110 NMOSWRAP
VG111 g111 0 2.6160216811778194
RB111 b111 4 10
X111 24 g111 4 b111 NMOSWRAP
VG112 g112 0 2.2486981882937607
RB112 b112 5 10
X112 24 g112 5 b112 NMOSWRAP
VG113 g113 0 1.2435923771378341
RB113 b113 6 10
X113 24 g113 6 b113 NMOSWRAP
VG114 g114 0 2.5344945492561930
RB114 b114 7 10
X114 24 g114 7 b114 NMOSWRAP
VG115 g115 0 1.4912643521174616
RB115 b115 8 10
X115 24 g115 8 b115 NMOSWRAP
VG116 g116 0 2.7027579927779040
RB116 b116 9 10
X116 24 g116 9 b116 NMOSWRAP
VG117 g117 0 1.9531821815896468
RB117 b117 10 10
X117 24 g117 10 b117 NMOSWRAP
VG118 g118 0 2.7043384046371322
RB118 b118 11 10
X118 24 g118 11 b118 NMOSWRAP
VG119 g119 0 2.2313289751944145
RB119 b119 12 10
X119 24 g119 12 b119 NMOSWRAP
VG120 g120 0 2.3131356995491013
RB120 b120 3 10
X120 25 g120 3 b120 NMOSWRAP
VG121 g121 0 1.7533109548167556
RB121 b121 4 10
X121 25 g121 4 b121 NMOSWRAP
VG122 g122 0 2.8902090868080599
RB122 b122 5 10
X122 25 g122 5 b122 NMOSWRAP
VG123 g123 0 2.1099754980740935
RB123 b123 6 10
X123 25 g123 6 b123 NMOSWRAP
VG124 g124 0 1.5596376213954493
RB124 b124 7 10
X124 25 g124 7 b124 NMOSWRAP
VG125 g125 0 2.0159830353198109
RB125 b125 8 10
X125 25 g125 8 b125 NMOSWRAP
VG126 g126 0 0.5479829957733338
RB126 b126 9 10
X126 25 g126 9 b126 NMOSWRAP
VG127 g127 0 1.2539370416863733
RB127 b127 10 10
X127 25 g127 10 b127 NMOSWRAP
VG128 g128 0 2.1504338437317125
RB128 b128 11 10
X128 25 g128 11 b128 NMOSWRAP
VG129 g129 0 1.2251940180261101
RB129 b129 12 10
X129 25 g129 12 b129 NMOSWRAP
VG130 g130 0 2.0450385724971039
RB130 b130 3 10
X130 26 g130 3 b130 NMOSWRAP
VG131 g131 0 1.5719217523644153
RB131 b131 4 10
X131 26 g131 4 b131 NMOSWRAP
VG132 g132 0 0.8386851605561256
RB132 b132 5 10
X132 26 g132 5 b132 NMOSWRAP
VG133 g133 0 1.2457058148900768
RB133 b133 6 10
X133 26 g133 6 b133 NMOSWRAP
VG134 g134 0 1.9249122767531621
RB134 b134 7 10
X134 26 g134 7 b134 NMOSWRAP
VG135 g135 0 1.9771819031204330
RB135 b135 8 10
X135 26 g135 8 b135 NMOSWRAP
VG136 g136 0 1.9358131221239470
RB136 b136 9 10
X136 26 g136 9 b136 NMOSWRAP
VG137 g137 0 2.1330020496428341
RB137 b137 10 10
X137 26 g137 10 b137 NMOSWRAP
VG138 g138 0 2.1302581750042222
RB138 b138 11 10
X138 26 g138 11 b138 NMOSWRAP
VG139 g139 0 1.5785460885849349
RB139 b139 12 10
X139 26 g139 12 b139 NMOSWRAP
VG140 g140 0 2.7413664896276577
RB140 b140 3 10
X140 27 g140 3 b140 NMOSWRAP
VG141 g141 0 1.4189046751197414
RB141 b141 4 10
X141 27 g141 4 b141 NMOSWRAP
VG142 g142 0 1.5896623131640670
RB142 b142 5 10
X142 27 g142 5 b142 NMOSWRAP
VG143 g143 0 2.7298083875391801
RB143 b143 6 10
X143 27 g143 6 b143 NMOSWRAP
VG144 g144 0 2.5154849726152144
RB144 b144 7 10
X144 27 g144 7 b144 NMOSWRAP
VG145 g145 0 2.2597214588509158
RB145 b145 8 10
X145 27 g145 8 b145 NMOSWRAP
VG146 g146 0 0.7505672182807528
RB146 b146 9 10
X146 27 g146 9 b146 NMOSWRAP
VG147 g147 0 2.7987065343616839
RB147 b147 10 10
X147 27 g147 10 b147 NMOSWRAP
VG148 g148 0 2.2856032488727784
RB148 b148 11 10
X148 27 g148 11 b148 NMOSWRAP
VG149 g149 0 2.9971175164196664
RB149 b149 12 10
X149 27 g149 12 b149 NMOSWRAP
VG150 g150 0 0.8736207616449844
RB150 b150 3 10
X150 28 g150 3 b150 NMOSWRAP
VG151 g151 0 2.6703151434205354
RB151 b151 4 10
X151 28 g151 4 b151 NMOSWRAP
VG152 g152 0 0.9062323366909371
RB152 b152 5 10
X152 28 g152 5 b152 NMOSWRAP
VG153 g153 0 2.0388989107096105
RB153 b153 6 10
X153 28 g153 6 b153 NMOSWRAP
VG154 g154 0 0.8095499571236038
RB154 b154 7 10
X154 28 g154 7 b154 NMOSWRAP
VG155 g155 0 2.6200205733055859
RB155 b155 8 10
X155 28 g155 8 b155 NMOSWRAP
VG156 g156 0 2.5182973968125268
RB156 b156 9 10
X156 28 g156 9 b156 NMOSWRAP
VG157 g157 0 1.9227518465364832
RB157 b157 10 10
X157 28 g157 10 b157 NMOSWRAP
VG158 g158 0 1.5179582430649992
RB158 b158 11 10
X158 28 g158 11 b158 NMOSWRAP
VG159 g159 0 0.6729174886378451
RB159 b159 12 10
X159 28 g159 12 b159 NMOSWRAP
VG160 g160 0 2.2435719328614092
RB160 b160 3 10
X160 29 g160 3 b160 NMOSWRAP
VG161 g161 0 1.6338567066951721
RB161 b161 4 10
X161 29 g161 4 b161 NMOSWRAP
VG162 g162 0 2.3051389986758699
RB162 b162 5 10
X162 29 g162 5 b162 NMOSWRAP
VG163 g163 0 2.6659558148215732
RB163 b163 6 10
X163 29 g163 6 b163 NMOSWRAP
VG164 g164 0 2.9388037625072148
RB164 b164 7 10
X164 29 g164 7 b164 NMOSWRAP
VG165 g165 0 2.6395083559815276
RB165 b165 8 10
X165 29 g165 8 b165 NMOSWRAP
VG166 g166 0 0.5292852104625050
RB166 b166 9 10
X166 29 g166 9 b166 NMOSWRAP
VG167 g167 0 1.3999451611959097
RB167 b167 10 10
X167 29 g167 10 b167 NMOSWRAP
VG168 g168 0 2.3249764060601450
RB168 b168 11 10
X168 29 g168 11 b168 NMOSWRAP
VG169 g169 0 0.9290741931536013
RB169 b169 12 10
X169 29 g169 12 b169 NMOSWRAP
VG170 g170 0 1.8025915155103232
RB170 b170 3 10
X170 30 g170 3 b170 NMOSWRAP
VG171 g171 0 0.6358449708481341
RB171 b171 4 10
X171 30 g171 4 b171 NMOSWRAP
VG172 g172 0 0.9999913122410002
RB172 b172 5 10
X172 30 g172 5 b172 NMOSWRAP
VG173 g173 0 0.5463044861515349
RB173 b173 6 10
X173 30 g173 6 b173 NMOSWRAP
VG174 g174 0 2.4842442583935513
RB174 b174 7 10
X174 30 g174 7 b174 NMOSWRAP
VG175 g175 0 1.0598117201509503
RB175 b175 8 10
X175 30 g175 8 b175 NMOSWRAP
VG176 g176 0 1.3633792017422568
RB176 b176 9 10
X176 30 g176 9 b176 NMOSWRAP
VG177 g177 0 2.8202032336639773
RB177 b177 10 10
X177 30 g177 10 b177 NMOSWRAP
VG178 g178 0 2.2610360048088318
RB178 b178 11 10
X178 30 g178 11 b178 NMOSWRAP
VG179 g179 0 0.5795973238282697
RB179 b179 12 10
X179 30 g179 12 b179 NMOSWRAP
VG180 g180 0 0.9117353912447819
RB180 b180 3 10
X180 31 g180 3 b180 NMOSWRAP
VG181 g181 0 2.0536960037494087
RB181 b181 4 10
X181 31 g181 4 b181 NMOSWRAP
VG182 g182 0 1.9430714715104189
RB182 b182 5 10
X182 31 g182 5 b182 NMOSWRAP
VG183 g183 0 1.0947320534362714
RB183 b183 6 10
X183 31 g183 6 b183 NMOSWRAP
VG184 g184 0 2.8355349948119843
RB184 b184 7 10
X184 31 g184 7 b184 NMOSWRAP
VG185 g185 0 2.0349148899147398
RB185 b185 8 10
X185 31 g185 8 b185 NMOSWRAP
VG186 g186 0 1.8390820075623957
RB186 b186 9 10
X186 31 g186 9 b186 NMOSWRAP
VG187 g187 0 1.9747749408864275
RB187 b187 10 10
X187 31 g187 10 b187 NMOSWRAP
VG188 g188 0 2.3253050737919239
RB188 b188 11 10
X188 31 g188 11 b188 NMOSWRAP
VG189 g189 0 1.2798624886990047
RB189 b189 12 10
X189 31 g189 12 b189 NMOSWRAP
VG190 g190 0 1.4955526555402296
RB190 b190 3 10
X190 32 g190 3 b190 NMOSWRAP
VG191 g191 0 1.0246093724378054
RB191 b191 4 10
X191 32 g191 4 b191 NMOSWRAP
VG192 g192 0 0.9654825147008403
RB192 b192 5 10
X192 32 g192 5 b192 NMOSWRAP
VG193 g193 0 2.8609309749598340
RB193 b193 6 10
X193 32 g193 6 b193 NMOSWRAP
VG194 g194 0 2.3488769876232189
RB194 b194 7 10
X194 32 g194 7 b194 NMOSWRAP
VG195 g195 0 1.7261470215439176
RB195 b195 8 10
X195 32 g195 8 b195 NMOSWRAP
VG196 g196 0 1.0685365699333080
RB196 b196 9 10
X196 32 g196 9 b196 NMOSWRAP
VG197 g197 0 1.1358912044259823
RB197 b197 10 10
X197 32 g197 10 b197 NMOSWRAP
VG198 g198 0 0.6450729008096890
RB198 b198 11 10
X198 32 g198 11 b198 NMOSWRAP
VG199 g199 0 1.5860415638953018
RB199 b199 12 10
X199 32 g199 12 b199 NMOSWRAP
VG200 g200 0 1.2794897049852565
RB200 b200 3 10
X200 33 g200 3 b200 NMOSWRAP
VG201 g201 0 2.2408587220386487
RB201 b201 4 10
X201 33 g201 4 b201 NMOSWRAP
VG202 g202 0 1.4443795982312022
RB202 b202 5 10
X202 33 g202 5 b202 NMOSWRAP
VG203 g203 0 0.9490091938990870
RB203 b203 6 10
X203 33 g203 6 b203 NMOSWRAP
VG204 g204 0 0.5616968209783281
RB204 b204 7 10
X204 33 g204 7 b204 NMOSWRAP
VG205 g205 0 0.6681240786581215
RB205 b205 8 10
X205 33 g205 8 b205 NMOSWRAP
VG206 g206 0 2.1984819337464181
RB206 b206 9 10
X206 33 g206 9 b206 NMOSWRAP
VG207 g207 0 1.6342421113901133
RB207 b207 10 10
X207 33 g207 10 b207 NMOSWRAP
VG208 g208 0 1.8414480277718055
RB208 b208 11 10
X208 33 g208 11 b208 NMOSWRAP
VG209 g209 0 2.7416782326008553
RB209 b209 12 10
X209 33 g209 12 b209 NMOSWRAP
VG210 g210 0 2.9758473684917610
RB210 b210 3 10
X210 34 g210 3 b210 NMOSWRAP
VG211 g211 0 1.0422424609961849
RB211 b211 4 10
X211 34 g211 4 b211 NMOSWRAP
VG212 g212 0 2.1576955077502520
RB212 b212 5 10
X212 34 g212 5 b212 NMOSWRAP
VG213 g213 0 1.1583059418428765
RB213 b213 6 10
X213 34 g213 6 b213 NMOSWRAP
VG214 g214 0 0.5516274986643217
RB214 b214 7 10
X214 34 g214 7 b214 NMOSWRAP
VG215 g215 0 2.3959466345903535
RB215 b215 8 10
X215 34 g215 8 b215 NMOSWRAP
VG216 g216 0 1.3000428770561696
RB216 b216 9 10
X216 34 g216 9 b216 NMOSWRAP
VG217 g217 0 1.4586597354297450
RB217 b217 10 10
X217 34 g217 10 b217 NMOSWRAP
VG218 g218 0 1.9707927838840142
RB218 b218 11 10
X218 34 g218 11 b218 NMOSWRAP
VG219 g219 0 2.5776211380904761
RB219 b219 12 10
X219 34 g219 12 b219 NMOSWRAP
VG220 g220 0 2.0724546089778717
RB220 b220 3 10
X220 35 g220 3 b220 NMOSWRAP
VG221 g221 0 2.6816266386184884
RB221 b221 4 10
X221 35 g221 4 b221 NMOSWRAP
VG222 g222 0 1.1838550870390894
RB222 b222 5 10
X222 35 g222 5 b222 NMOSWRAP
VG223 g223 0 2.4951170847814090
RB223 b223 6 10
X223 35 g223 6 b223 NMOSWRAP
VG224 g224 0 0.9640898607648805
RB224 b224 7 10
X224 35 g224 7 b224 NMOSWRAP
VG225 g225 0 2.8819791424298615
RB225 b225 8 10
X225 35 g225 8 b225 NMOSWRAP
VG226 g226 0 2.2187206909695383
RB226 b226 9 10
X226 35 g226 9 b226 NMOSWRAP
VG227 g227 0 1.0387691927838962
RB227 b227 10 10
X227 35 g227 10 b227 NMOSWRAP
VG228 g228 0 2.8684264762223108
RB228 b228 11 10
X228 35 g228 11 b228 NMOSWRAP
VG229 g229 0 2.3271395169253948
RB229 b229 12 10
X229 35 g229 12 b229 NMOSWRAP
VG230 g230 0 1.1348541064875646
RB230 b230 3 10
X230 36 g230 3 b230 NMOSWRAP
VG231 g231 0 1.0332799434187050
RB231 b231 4 10
X231 36 g231 4 b231 NMOSWRAP
VG232 g232 0 1.7955017848266581
RB232 b232 5 10
X232 36 g232 5 b232 NMOSWRAP
VG233 g233 0 0.5641567951363289
RB233 b233 6 10
X233 36 g233 6 b233 NMOSWRAP
VG234 g234 0 1.0186751886027734
RB234 b234 7 10
X234 36 g234 7 b234 NMOSWRAP
VG235 g235 0 1.5617136718787656
RB235 b235 8 10
X235 36 g235 8 b235 NMOSWRAP
VG236 g236 0 1.4354249508355639
RB236 b236 9 10
X236 36 g236 9 b236 NMOSWRAP
VG237 g237 0 1.6589385609120266
RB237 b237 10 10
X237 36 g237 10 b237 NMOSWRAP
VG238 g238 0 1.1940717657368298
RB238 b238 11 10
X238 36 g238 11 b238 NMOSWRAP
VG239 g239 0 1.9669608661454219
RB239 b239 12 10
X239 36 g239 12 b239 NMOSWRAP
VG240 g240 0 2.6596390148080786
RB240 b240 3 10
X240 37 g240 3 b240 NMOSWRAP
VG241 g241 0 0.7938296399050827
RB241 b241 4 10
X241 37 g241 4 b241 NMOSWRAP
VG242 g242 0 1.7934477678852854
RB242 b242 5 10
X242 37 g242 5 b242 NMOSWRAP
VG243 g243 0 0.8301702658628833
RB243 b243 6 10
X243 37 g243 6 b243 NMOSWRAP
VG244 g244 0 2.2921492029814843
RB244 b244 7 10
X244 37 g244 7 b244 NMOSWRAP
VG245 g245 0 1.4901492570182344
RB245 b245 8 10
X245 37 g245 8 b245 NMOSWRAP
VG246 g246 0 1.9135532796462724
RB246 b246 9 10
X246 37 g246 9 b246 NMOSWRAP
VG247 g247 0 0.9581995905351965
RB247 b247 10 10
X247 37 g247 10 b247 NMOSWRAP
VG248 g248 0 0.8621193983584431
RB248 b248 11 10
X248 37 g248 11 b248 NMOSWRAP
VG249 g249 0 1.7201407016223864
RB249 b249 12 10
X249 37 g249 12 b249 NMOSWRAP
VG250 g250 0 1.3890318446248890
RB250 b250 3 10
X250 38 g250 3 b250 NMOSWRAP
VG251 g251 0 2.8510798631320324
RB251 b251 4 10
X251 38 g251 4 b251 NMOSWRAP
VG252 g252 0 2.4133131345174132
RB252 b252 5 10
X252 38 g252 5 b252 NMOSWRAP
VG253 g253 0 2.3716590496263681
RB253 b253 6 10
X253 38 g253 6 b253 NMOSWRAP
VG254 g254 0 2.7592993493648335
RB254 b254 7 10
X254 38 g254 7 b254 NMOSWRAP
VG255 g255 0 0.7085560886050464
RB255 b255 8 10
X255 38 g255 8 b255 NMOSWRAP
VG256 g256 0 1.8804811748060164
RB256 b256 9 10
X256 38 g256 9 b256 NMOSWRAP
VG257 g257 0 1.9611901723894221
RB257 b257 10 10
X257 38 g257 10 b257 NMOSWRAP
VG258 g258 0 2.9048409463680724
RB258 b258 11 10
X258 38 g258 11 b258 NMOSWRAP
VG259 g259 0 1.2303688169813722
RB259 b259 12 10
X259 38 g259 12 b259 NMOSWRAP
VG260 g260 0 1.1020719497886171
RB260 b260 3 10
X260 39 g260 3 b260 NMOSWRAP
VG261 g261 0 0.7507348556637445
RB261 b261 4 10
X261 39 g261 4 b261 NMOSWRAP
VG262 g262 0 0.5410740739786855
RB262 b262 5 10
X262 39 g262 5 b262 NMOSWRAP
VG263 g263 0 2.8238232919804762
RB263 b263 6 10
X263 39 g263 6 b263 NMOSWRAP
VG264 g264 0 2.1747913664772751
RB264 b264 7 10
X264 39 g264 7 b264 NMOSWRAP
VG265 g265 0 2.4628822800578445
RB265 b265 8 10
X265 39 g265 8 b265 NMOSWRAP
VG266 g266 0 1.2043252643848728
RB266 b266 9 10
X266 39 g266 9 b266 NMOSWRAP
VG267 g267 0 1.9660254154658168
RB267 b267 10 10
X267 39 g267 10 b267 NMOSWRAP
VG268 g268 0 0.6598881653024529
RB268 b268 11 10
X268 39 g268 11 b268 NMOSWRAP
VG269 g269 0 1.7140689898365573
RB269 b269 12 10
X269 39 g269 12 b269 NMOSWRAP
VG270 g270 0 2.9437378493611170
RB270 b270 3 10
X270 40 g270 3 b270 NMOSWRAP
VG271 g271 0 2.6912631132914768
RB271 b271 4 10
X271 40 g271 4 b271 NMOSWRAP
VG272 g272 0 1.3453973795921141
RB272 b272 5 10
X272 40 g272 5 b272 NMOSWRAP
VG273 g273 0 2.9039253863537464
RB273 b273 6 10
X273 40 g273 6 b273 NMOSWRAP
VG274 g274 0 1.0792540661780112
RB274 b274 7 10
X274 40 g274 7 b274 NMOSWRAP
VG275 g275 0 2.8732970560392035
RB275 b275 8 10
X275 40 g275 8 b275 NMOSWRAP
VG276 g276 0 2.8534442617662465
RB276 b276 9 10
X276 40 g276 9 b276 NMOSWRAP
VG277 g277 0 2.4980064683809795
RB277 b277 10 10
X277 40 g277 10 b277 NMOSWRAP
VG278 g278 0 2.0761198421669778
RB278 b278 11 10
X278 40 g278 11 b278 NMOSWRAP
VG279 g279 0 2.6857199165623675
RB279 b279 12 10
X279 40 g279 12 b279 NMOSWRAP
VG280 g280 0 1.2325507112694918
RB280 b280 3 10
X280 41 g280 3 b280 NMOSWRAP
VG281 g281 0 2.6223588882822955
RB281 b281 4 10
X281 41 g281 4 b281 NMOSWRAP
VG282 g282 0 2.0446917297938096
RB282 b282 5 10
X282 41 g282 5 b282 NMOSWRAP
VG283 g283 0 0.5330921443972487
RB283 b283 6 10
X283 41 g283 6 b283 NMOSWRAP
VG284 g284 0 1.3680837948305489
RB284 b284 7 10
X284 41 g284 7 b284 NMOSWRAP
VG285 g285 0 0.8703521523704125
RB285 b285 8 10
X285 41 g285 8 b285 NMOSWRAP
VG286 g286 0 2.9545734745456329
RB286 b286 9 10
X286 41 g286 9 b286 NMOSWRAP
VG287 g287 0 1.6959257675999702
RB287 b287 10 10
X287 41 g287 10 b287 NMOSWRAP
VG288 g288 0 1.7434784137466568
RB288 b288 11 10
X288 41 g288 11 b288 NMOSWRAP
VG289 g289 0 2.0986812909968089
RB289 b289 12 10
X289 41 g289 12 b289 NMOSWRAP
VG290 g290 0 1.4214615153240437
RB290 b290 3 10
X290 42 g290 3 b290 NMOSWRAP
VG291 g291 0 0.8422506792139973
RB291 b291 4 10
X291 42 g291 4 b291 NMOSWRAP
VG292 g292 0 2.5552943329856137
RB292 b292 5 10
X292 42 g292 5 b292 NMOSWRAP
VG293 g293 0 0.9746197797568950
RB293 b293 6 10
X293 42 g293 6 b293 NMOSWRAP
VG294 g294 0 1.7782974563661400
RB294 b294 7 10
X294 42 g294 7 b294 NMOSWRAP
VG295 g295 0 1.0607925724368481
RB295 b295 8 10
X295 42 g295 8 b295 NMOSWRAP
VG296 g296 0 0.7446112112350851
RB296 b296 9 10
X296 42 g296 9 b296 NMOSWRAP
VG297 g297 0 2.6554787935542081
RB297 b297 10 10
X297 42 g297 10 b297 NMOSWRAP
VG298 g298 0 2.9322987225578259
RB298 b298 11 10
X298 42 g298 11 b298 NMOSWRAP
VG299 g299 0 2.9020866451575005
RB299 b299 12 10
X299 42 g299 12 b299 NMOSWRAP
VG300 g300 0 2.7663887480529472
RB300 b300 3 10
X300 43 g300 3 b300 NMOSWRAP
VG301 g301 0 2.4351183317465970
RB301 b301 4 10
X301 43 g301 4 b301 NMOSWRAP
VG302 g302 0 1.3328628800716049
RB302 b302 5 10
X302 43 g302 5 b302 NMOSWRAP
VG303 g303 0 0.7027534749699920
RB303 b303 6 10
X303 43 g303 6 b303 NMOSWRAP
VG304 g304 0 1.5181029285345184
RB304 b304 7 10
X304 43 g304 7 b304 NMOSWRAP
VG305 g305 0 1.0805853554273568
RB305 b305 8 10
X305 43 g305 8 b305 NMOSWRAP
VG306 g306 0 0.8312190868949574
RB306 b306 9 10
X306 43 g306 9 b306 NMOSWRAP
VG307 g307 0 0.6335679544670632
RB307 b307 10 10
X307 43 g307 10 b307 NMOSWRAP
VG308 g308 0 2.3139859105264469
RB308 b308 11 10
X308 43 g308 11 b308 NMOSWRAP
VG309 g309 0 0.5285686465625776
RB309 b309 12 10
X309 43 g309 12 b309 NMOSWRAP
VG310 g310 0 2.4264518712569405
RB310 b310 3 10
X310 44 g310 3 b310 NMOSWRAP
VG311 g311 0 0.8673666135009377
RB311 b311 4 10
X311 44 g311 4 b311 NMOSWRAP
VG312 g312 0 0.6988052064668894
RB312 b312 5 10
X312 44 g312 5 b312 NMOSWRAP
VG313 g313 0 0.7240075855965135
RB313 b313 6 10
X313 44 g313 6 b313 NMOSWRAP
VG314 g314 0 2.1801195183847861
RB314 b314 7 10
X314 44 g314 7 b314 NMOSWRAP
VG315 g315 0 1.1134180246321119
RB315 b315 8 10
X315 44 g315 8 b315 NMOSWRAP
VG316 g316 0 1.5513486667002461
RB316 b316 9 10
X316 44 g316 9 b316 NMOSWRAP
VG317 g317 0 1.8934219783097923
RB317 b317 10 10
X317 44 g317 10 b317 NMOSWRAP
VG318 g318 0 2.6513779345719843
RB318 b318 11 10
X318 44 g318 11 b318 NMOSWRAP
VG319 g319 0 2.3176106567783208
RB319 b319 12 10
X319 44 g319 12 b319 NMOSWRAP
VG320 g320 0 1.1758197630967866
RB320 b320 3 10
X320 45 g320 3 b320 NMOSWRAP
VG321 g321 0 0.8287069982278190
RB321 b321 4 10
X321 45 g321 4 b321 NMOSWRAP
VG322 g322 0 0.6384358010529949
RB322 b322 5 10
X322 45 g322 5 b322 NMOSWRAP
VG323 g323 0 1.2539965862023563
RB323 b323 6 10
X323 45 g323 6 b323 NMOSWRAP
VG324 g324 0 1.1552953730991957
RB324 b324 7 10
X324 45 g324 7 b324 NMOSWRAP
VG325 g325 0 1.6403514170011992
RB325 b325 8 10
X325 45 g325 8 b325 NMOSWRAP
VG326 g326 0 2.2082033388692013
RB326 b326 9 10
X326 45 g326 9 b326 NMOSWRAP
VG327 g327 0 2.2390636140971427
RB327 b327 10 10
X327 45 g327 10 b327 NMOSWRAP
VG328 g328 0 1.2087971164554165
RB328 b328 11 10
X328 45 g328 11 b328 NMOSWRAP
VG329 g329 0 1.4498173897503013
RB329 b329 12 10
X329 45 g329 12 b329 NMOSWRAP
VG330 g330 0 0.9528774043422577
RB330 b330 3 10
X330 46 g330 3 b330 NMOSWRAP
VG331 g331 0 2.4713637807662967
RB331 b331 4 10
X331 46 g331 4 b331 NMOSWRAP
VG332 g332 0 0.6421201910831007
RB332 b332 5 10
X332 46 g332 5 b332 NMOSWRAP
VG333 g333 0 2.2424931043124685
RB333 b333 6 10
X333 46 g333 6 b333 NMOSWRAP
VG334 g334 0 2.4467384898527582
RB334 b334 7 10
X334 46 g334 7 b334 NMOSWRAP
VG335 g335 0 2.4435189046218828
RB335 b335 8 10
X335 46 g335 8 b335 NMOSWRAP
VG336 g336 0 1.1485564108633874
RB336 b336 9 10
X336 46 g336 9 b336 NMOSWRAP
VG337 g337 0 1.4345328448314036
RB337 b337 10 10
X337 46 g337 10 b337 NMOSWRAP
VG338 g338 0 1.9689990879909725
RB338 b338 11 10
X338 46 g338 11 b338 NMOSWRAP
VG339 g339 0 1.1820547560611676
RB339 b339 12 10
X339 46 g339 12 b339 NMOSWRAP
VG340 g340 0 1.4271319980447217
RB340 b340 3 10
X340 47 g340 3 b340 NMOSWRAP
VG341 g341 0 0.9926357004640991
RB341 b341 4 10
X341 47 g341 4 b341 NMOSWRAP
VG342 g342 0 1.6496397093900184
RB342 b342 5 10
X342 47 g342 5 b342 NMOSWRAP
VG343 g343 0 0.6115307531352852
RB343 b343 6 10
X343 47 g343 6 b343 NMOSWRAP
VG344 g344 0 2.4994897114265449
RB344 b344 7 10
X344 47 g344 7 b344 NMOSWRAP
VG345 g345 0 0.6923911174665818
RB345 b345 8 10
X345 47 g345 8 b345 NMOSWRAP
VG346 g346 0 1.7970878720788150
RB346 b346 9 10
X346 47 g346 9 b346 NMOSWRAP
VG347 g347 0 1.2670252488629903
RB347 b347 10 10
X347 47 g347 10 b347 NMOSWRAP
VG348 g348 0 1.9438573720784387
RB348 b348 11 10
X348 47 g348 11 b348 NMOSWRAP
VG349 g349 0 2.8985833520835627
RB349 b349 12 10
X349 47 g349 12 b349 NMOSWRAP
VG350 g350 0 2.1139256111400098
RB350 b350 3 10
X350 48 g350 3 b350 NMOSWRAP
VG351 g351 0 0.5884060893887273
RB351 b351 4 10
X351 48 g351 4 b351 NMOSWRAP
VG352 g352 0 1.5760060987701530
RB352 b352 5 10
X352 48 g352 5 b352 NMOSWRAP
VG353 g353 0 1.7750421307956255
RB353 b353 6 10
X353 48 g353 6 b353 NMOSWRAP
VG354 g354 0 1.8404437367586299
RB354 b354 7 10
X354 48 g354 7 b354 NMOSWRAP
VG355 g355 0 2.2034812765095948
RB355 b355 8 10
X355 48 g355 8 b355 NMOSWRAP
VG356 g356 0 1.1939902443294153
RB356 b356 9 10
X356 48 g356 9 b356 NMOSWRAP
VG357 g357 0 0.8221514136658005
RB357 b357 10 10
X357 48 g357 10 b357 NMOSWRAP
VG358 g358 0 1.4816891913677359
RB358 b358 11 10
X358 48 g358 11 b358 NMOSWRAP
VG359 g359 0 2.8910143069898719
RB359 b359 12 10
X359 48 g359 12 b359 NMOSWRAP
VG360 g360 0 0.9678272293771119
RB360 b360 3 10
X360 49 g360 3 b360 NMOSWRAP
VG361 g361 0 2.7599598873205924
RB361 b361 4 10
X361 49 g361 4 b361 NMOSWRAP
VG362 g362 0 1.8595148751933159
RB362 b362 5 10
X362 49 g362 5 b362 NMOSWRAP
VG363 g363 0 1.6422785541144145
RB363 b363 6 10
X363 49 g363 6 b363 NMOSWRAP
VG364 g364 0 2.7051035255747240
RB364 b364 7 10
X364 49 g364 7 b364 NMOSWRAP
VG365 g365 0 1.6465099044214646
RB365 b365 8 10
X365 49 g365 8 b365 NMOSWRAP
VG366 g366 0 2.3104190915288583
RB366 b366 9 10
X366 49 g366 9 b366 NMOSWRAP
VG367 g367 0 1.4975633042577550
RB367 b367 10 10
X367 49 g367 10 b367 NMOSWRAP
VG368 g368 0 2.7601109822523942
RB368 b368 11 10
X368 49 g368 11 b368 NMOSWRAP
VG369 g369 0 2.2250625504780683
RB369 b369 12 10
X369 49 g369 12 b369 NMOSWRAP
VG370 g370 0 2.2490551356262918
RB370 b370 3 10
X370 50 g370 3 b370 NMOSWRAP
VG371 g371 0 1.3193010038927973
RB371 b371 4 10
X371 50 g371 4 b371 NMOSWRAP
VG372 g372 0 2.3919466068422230
RB372 b372 5 10
X372 50 g372 5 b372 NMOSWRAP
VG373 g373 0 2.0901526386178535
RB373 b373 6 10
X373 50 g373 6 b373 NMOSWRAP
VG374 g374 0 1.1000506834492738
RB374 b374 7 10
X374 50 g374 7 b374 NMOSWRAP
VG375 g375 0 0.9013470562131410
RB375 b375 8 10
X375 50 g375 8 b375 NMOSWRAP
VG376 g376 0 2.4909786862933294
RB376 b376 9 10
X376 50 g376 9 b376 NMOSWRAP
VG377 g377 0 2.8979165075880564
RB377 b377 10 10
X377 50 g377 10 b377 NMOSWRAP
VG378 g378 0 1.6453470681501070
RB378 b378 11 10
X378 50 g378 11 b378 NMOSWRAP
VG379 g379 0 1.9774604133092124
RB379 b379 12 10
X379 50 g379 12 b379 NMOSWRAP
VG380 g380 0 2.6443066104838864
RB380 b380 3 10
X380 51 g380 3 b380 NMOSWRAP
VG381 g381 0 1.6430586333846426
RB381 b381 4 10
X381 51 g381 4 b381 NMOSWRAP
VG382 g382 0 2.8796861920818406
RB382 b382 5 10
X382 51 g382 5 b382 NMOSWRAP
VG383 g383 0 1.9393779051121811
RB383 b383 6 10
X383 51 g383 6 b383 NMOSWRAP
VG384 g384 0 2.5519178017532873
RB384 b384 7 10
X384 51 g384 7 b384 NMOSWRAP
VG385 g385 0 2.7721092960318461
RB385 b385 8 10
X385 51 g385 8 b385 NMOSWRAP
VG386 g386 0 2.5388095469214220
RB386 b386 9 10
X386 51 g386 9 b386 NMOSWRAP
VG387 g387 0 0.8985361586223899
RB387 b387 10 10
X387 51 g387 10 b387 NMOSWRAP
VG388 g388 0 2.0722460976542507
RB388 b388 11 10
X388 51 g388 11 b388 NMOSWRAP
VG389 g389 0 1.4960856465491927
RB389 b389 12 10
X389 51 g389 12 b389 NMOSWRAP
VG390 g390 0 0.6567823800583643
RB390 b390 3 10
X390 52 g390 3 b390 NMOSWRAP
VG391 g391 0 1.5600806297246048
RB391 b391 4 10
X391 52 g391 4 b391 NMOSWRAP
VG392 g392 0 1.1467101672235192
RB392 b392 5 10
X392 52 g392 5 b392 NMOSWRAP
VG393 g393 0 2.6225957710712771
RB393 b393 6 10
X393 52 g393 6 b393 NMOSWRAP
VG394 g394 0 0.5832615663667404
RB394 b394 7 10
X394 52 g394 7 b394 NMOSWRAP
VG395 g395 0 2.8974568046586837
RB395 b395 8 10
X395 52 g395 8 b395 NMOSWRAP
VG396 g396 0 1.3884221211798240
RB396 b396 9 10
X396 52 g396 9 b396 NMOSWRAP
VG397 g397 0 1.3917672260063572
RB397 b397 10 10
X397 52 g397 10 b397 NMOSWRAP
VG398 g398 0 0.5408212567092697
RB398 b398 11 10
X398 52 g398 11 b398 NMOSWRAP
VG399 g399 0 0.9630808130904598
RB399 b399 12 10
X399 52 g399 12 b399 NMOSWRAP
VG400 g400 0 1.5031487520090219
RB400 b400 3 10
X400 53 g400 3 b400 NMOSWRAP
VG401 g401 0 2.8232285432567847
RB401 b401 4 10
X401 53 g401 4 b401 NMOSWRAP
VG402 g402 0 0.7490373255531784
RB402 b402 5 10
X402 53 g402 5 b402 NMOSWRAP
VG403 g403 0 2.8632538336976987
RB403 b403 6 10
X403 53 g403 6 b403 NMOSWRAP
VG404 g404 0 2.6737213263665804
RB404 b404 7 10
X404 53 g404 7 b404 NMOSWRAP
VG405 g405 0 1.6354059922688795
RB405 b405 8 10
X405 53 g405 8 b405 NMOSWRAP
VG406 g406 0 1.3167522044206501
RB406 b406 9 10
X406 53 g406 9 b406 NMOSWRAP
VG407 g407 0 1.0818603231976422
RB407 b407 10 10
X407 53 g407 10 b407 NMOSWRAP
VG408 g408 0 2.0361617661921860
RB408 b408 11 10
X408 53 g408 11 b408 NMOSWRAP
VG409 g409 0 0.5826864786887640
RB409 b409 12 10
X409 53 g409 12 b409 NMOSWRAP
VG410 g410 0 0.5390151611170706
RB410 b410 3 10
X410 54 g410 3 b410 NMOSWRAP
VG411 g411 0 1.5719893062455945
RB411 b411 4 10
X411 54 g411 4 b411 NMOSWRAP
VG412 g412 0 0.6701851849368006
RB412 b412 5 10
X412 54 g412 5 b412 NMOSWRAP
VG413 g413 0 1.1298524706152322
RB413 b413 6 10
X413 54 g413 6 b413 NMOSWRAP
VG414 g414 0 1.0529022883652095
RB414 b414 7 10
X414 54 g414 7 b414 NMOSWRAP
VG415 g415 0 1.1329779843071299
RB415 b415 8 10
X415 54 g415 8 b415 NMOSWRAP
VG416 g416 0 0.8276380780381444
RB416 b416 9 10
X416 54 g416 9 b416 NMOSWRAP
VG417 g417 0 0.5300905572441357
RB417 b417 10 10
X417 54 g417 10 b417 NMOSWRAP
VG418 g418 0 0.7887107428468703
RB418 b418 11 10
X418 54 g418 11 b418 NMOSWRAP
VG419 g419 0 2.0462006487818698
RB419 b419 12 10
X419 54 g419 12 b419 NMOSWRAP
VG420 g420 0 2.9356405320451255
RB420 b420 3 10
X420 55 g420 3 b420 NMOSWRAP
VG421 g421 0 2.9758625039022348
RB421 b421 4 10
X421 55 g421 4 b421 NMOSWRAP
VG422 g422 0 1.5226352384326540
RB422 b422 5 10
X422 55 g422 5 b422 NMOSWRAP
VG423 g423 0 0.9073860651165134
RB423 b423 6 10
X423 55 g423 6 b423 NMOSWRAP
VG424 g424 0 2.0969043934163230
RB424 b424 7 10
X424 55 g424 7 b424 NMOSWRAP
VG425 g425 0 1.7257633663718428
RB425 b425 8 10
X425 55 g425 8 b425 NMOSWRAP
VG426 g426 0 2.9735244432110788
RB426 b426 9 10
X426 55 g426 9 b426 NMOSWRAP
VG427 g427 0 0.6632605178794505
RB427 b427 10 10
X427 55 g427 10 b427 NMOSWRAP
VG428 g428 0 2.4580860957845330
RB428 b428 11 10
X428 55 g428 11 b428 NMOSWRAP
VG429 g429 0 1.2209962433287349
RB429 b429 12 10
X429 55 g429 12 b429 NMOSWRAP
VG430 g430 0 1.1035465501914350
RB430 b430 3 10
X430 56 g430 3 b430 NMOSWRAP
VG431 g431 0 2.1562614288316899
RB431 b431 4 10
X431 56 g431 4 b431 NMOSWRAP
VG432 g432 0 1.1151579624774111
RB432 b432 5 10
X432 56 g432 5 b432 NMOSWRAP
VG433 g433 0 2.1646477938979691
RB433 b433 6 10
X433 56 g433 6 b433 NMOSWRAP
VG434 g434 0 1.7932712930057220
RB434 b434 7 10
X434 56 g434 7 b434 NMOSWRAP
VG435 g435 0 1.5602224710896233
RB435 b435 8 10
X435 56 g435 8 b435 NMOSWRAP
VG436 g436 0 1.8867195216535475
RB436 b436 9 10
X436 56 g436 9 b436 NMOSWRAP
VG437 g437 0 1.2176287997990745
RB437 b437 10 10
X437 56 g437 10 b437 NMOSWRAP
VG438 g438 0 2.2664367656824473
RB438 b438 11 10
X438 56 g438 11 b438 NMOSWRAP
VG439 g439 0 1.5371421733339101
RB439 b439 12 10
X439 56 g439 12 b439 NMOSWRAP
VG440 g440 0 1.4013639012147308
RB440 b440 3 10
X440 57 g440 3 b440 NMOSWRAP
VG441 g441 0 2.5716422863893444
RB441 b441 4 10
X441 57 g441 4 b441 NMOSWRAP
VG442 g442 0 2.8124172798829803
RB442 b442 5 10
X442 57 g442 5 b442 NMOSWRAP
VG443 g443 0 0.6150182772182423
RB443 b443 6 10
X443 57 g443 6 b443 NMOSWRAP
VG444 g444 0 1.0815674820744139
RB444 b444 7 10
X444 57 g444 7 b444 NMOSWRAP
VG445 g445 0 1.3712984237314081
RB445 b445 8 10
X445 57 g445 8 b445 NMOSWRAP
VG446 g446 0 2.5374161984256185
RB446 b446 9 10
X446 57 g446 9 b446 NMOSWRAP
VG447 g447 0 2.9637285691082438
RB447 b447 10 10
X447 57 g447 10 b447 NMOSWRAP
VG448 g448 0 2.9224292616758794
RB448 b448 11 10
X448 57 g448 11 b448 NMOSWRAP
VG449 g449 0 2.7623708638748172
RB449 b449 12 10
X449 57 g449 12 b449 NMOSWRAP
VG450 g450 0 1.2413906626600748
RB450 b450 3 10
X450 58 g450 3 b450 NMOSWRAP
VG451 g451 0 2.9800281085361853
RB451 b451 4 10
X451 58 g451 4 b451 NMOSWRAP
VG452 g452 0 1.1235501026411281
RB452 b452 5 10
X452 58 g452 5 b452 NMOSWRAP
VG453 g453 0 0.7647653872055805
RB453 b453 6 10
X453 58 g453 6 b453 NMOSWRAP
VG454 g454 0 2.8773815276384851
RB454 b454 7 10
X454 58 g454 7 b454 NMOSWRAP
VG455 g455 0 1.0835506386702407
RB455 b455 8 10
X455 58 g455 8 b455 NMOSWRAP
VG456 g456 0 2.2244206626943761
RB456 b456 9 10
X456 58 g456 9 b456 NMOSWRAP
VG457 g457 0 0.6458908974514717
RB457 b457 10 10
X457 58 g457 10 b457 NMOSWRAP
VG458 g458 0 2.3267727478186906
RB458 b458 11 10
X458 58 g458 11 b458 NMOSWRAP
VG459 g459 0 2.7043005308345993
RB459 b459 12 10
X459 58 g459 12 b459 NMOSWRAP
VG460 g460 0 1.1810922386649063
RB460 b460 3 10
X460 59 g460 3 b460 NMOSWRAP
VG461 g461 0 1.4476422401935714
RB461 b461 4 10
X461 59 g461 4 b461 NMOSWRAP
VG462 g462 0 1.4357404583022901
RB462 b462 5 10
X462 59 g462 5 b462 NMOSWRAP
VG463 g463 0 2.3719706438503327
RB463 b463 6 10
X463 59 g463 6 b463 NMOSWRAP
VG464 g464 0 1.0945181063475971
RB464 b464 7 10
X464 59 g464 7 b464 NMOSWRAP
VG465 g465 0 0.9296327476191075
RB465 b465 8 10
X465 59 g465 8 b465 NMOSWRAP
VG466 g466 0 1.6232291217193451
RB466 b466 9 10
X466 59 g466 9 b466 NMOSWRAP
VG467 g467 0 1.2611710184432987
RB467 b467 10 10
X467 59 g467 10 b467 NMOSWRAP
VG468 g468 0 2.5979728056466311
RB468 b468 11 10
X468 59 g468 11 b468 NMOSWRAP
VG469 g469 0 1.0943545650390969
RB469 b469 12 10
X469 59 g469 12 b469 NMOSWRAP
VG470 g470 0 1.7559736437231537
RB470 b470 3 10
X470 60 g470 3 b470 NMOSWRAP
VG471 g471 0 2.8564589992448259
RB471 b471 4 10
X471 60 g471 4 b471 NMOSWRAP
VG472 g472 0 2.0849942443616518
RB472 b472 5 10
X472 60 g472 5 b472 NMOSWRAP
VG473 g473 0 2.6682235136561618
RB473 b473 6 10
X473 60 g473 6 b473 NMOSWRAP
VG474 g474 0 2.8505242233869184
RB474 b474 7 10
X474 60 g474 7 b474 NMOSWRAP
VG475 g475 0 2.3769121547158800
RB475 b475 8 10
X475 60 g475 8 b475 NMOSWRAP
VG476 g476 0 2.2489376505618783
RB476 b476 9 10
X476 60 g476 9 b476 NMOSWRAP
VG477 g477 0 2.9199139165105676
RB477 b477 10 10
X477 60 g477 10 b477 NMOSWRAP
VG478 g478 0 2.9860019741191985
RB478 b478 11 10
X478 60 g478 11 b478 NMOSWRAP
VG479 g479 0 1.6295542066743991
RB479 b479 12 10
X479 60 g479 12 b479 NMOSWRAP
VG480 g480 0 0.6771744454605209
RB480 b480 3 10
X480 61 g480 3 b480 NMOSWRAP
VG481 g481 0 1.2319850786012971
RB481 b481 4 10
X481 61 g481 4 b481 NMOSWRAP
VG482 g482 0 0.8808867642193261
RB482 b482 5 10
X482 61 g482 5 b482 NMOSWRAP
VG483 g483 0 1.5437159369900295
RB483 b483 6 10
X483 61 g483 6 b483 NMOSWRAP
VG484 g484 0 0.8282233211831400
RB484 b484 7 10
X484 61 g484 7 b484 NMOSWRAP
VG485 g485 0 2.0102945100522049
RB485 b485 8 10
X485 61 g485 8 b485 NMOSWRAP
VG486 g486 0 1.4570201478946352
RB486 b486 9 10
X486 61 g486 9 b486 NMOSWRAP
VG487 g487 0 2.7384647107205251
RB487 b487 10 10
X487 61 g487 10 b487 NMOSWRAP
VG488 g488 0 2.9194866794962548
RB488 b488 11 10
X488 61 g488 11 b488 NMOSWRAP
VG489 g489 0 1.8672122541735554
RB489 b489 12 10
X489 61 g489 12 b489 NMOSWRAP
VG490 g490 0 1.1870589246689915
RB490 b490 3 10
X490 62 g490 3 b490 NMOSWRAP
VG491 g491 0 1.9805760469045919
RB491 b491 4 10
X491 62 g491 4 b491 NMOSWRAP
VG492 g492 0 2.7419028955610245
RB492 b492 5 10
X492 62 g492 5 b492 NMOSWRAP
VG493 g493 0 1.5168333645893708
RB493 b493 6 10
X493 62 g493 6 b493 NMOSWRAP
VG494 g494 0 1.8801956917299272
RB494 b494 7 10
X494 62 g494 7 b494 NMOSWRAP
VG495 g495 0 1.1791319190153646
RB495 b495 8 10
X495 62 g495 8 b495 NMOSWRAP
VG496 g496 0 1.6386103736250675
RB496 b496 9 10
X496 62 g496 9 b496 NMOSWRAP
VG497 g497 0 1.5042838384489965
RB497 b497 10 10
X497 62 g497 10 b497 NMOSWRAP
VG498 g498 0 1.1210336627074275
RB498 b498 11 10
X498 62 g498 11 b498 NMOSWRAP
VG499 g499 0 1.7646659595632710
RB499 b499 12 10
X499 62 g499 12 b499 NMOSWRAP
VG500 g500 0 1.2759520649495286
RB500 b500 3 10
X500 63 g500 3 b500 NMOSWRAP
VG501 g501 0 1.4325871597018687
RB501 b501 4 10
X501 63 g501 4 b501 NMOSWRAP
VG502 g502 0 1.8124261056356605
RB502 b502 5 10
X502 63 g502 5 b502 NMOSWRAP
VG503 g503 0 2.3764875573224686
RB503 b503 6 10
X503 63 g503 6 b503 NMOSWRAP
VG504 g504 0 1.3337686644781883
RB504 b504 7 10
X504 63 g504 7 b504 NMOSWRAP
VG505 g505 0 2.8103969165519089
RB505 b505 8 10
X505 63 g505 8 b505 NMOSWRAP
VG506 g506 0 2.6557963670897560
RB506 b506 9 10
X506 63 g506 9 b506 NMOSWRAP
VG507 g507 0 0.6217257399388214
RB507 b507 10 10
X507 63 g507 10 b507 NMOSWRAP
VG508 g508 0 1.1341063106420570
RB508 b508 11 10
X508 63 g508 11 b508 NMOSWRAP
VG509 g509 0 1.6153387816480049
RB509 b509 12 10
X509 63 g509 12 b509 NMOSWRAP
VG510 g510 0 0.7615697218561852
RB510 b510 3 10
X510 64 g510 3 b510 NMOSWRAP
VG511 g511 0 1.3711899725837426
RB511 b511 4 10
X511 64 g511 4 b511 NMOSWRAP
VG512 g512 0 2.3502438140442061
RB512 b512 5 10
X512 64 g512 5 b512 NMOSWRAP
VG513 g513 0 2.2012862028570646
RB513 b513 6 10
X513 64 g513 6 b513 NMOSWRAP
VG514 g514 0 2.0559610714150121
RB514 b514 7 10
X514 64 g514 7 b514 NMOSWRAP
VG515 g515 0 2.2763210068058641
RB515 b515 8 10
X515 64 g515 8 b515 NMOSWRAP
VG516 g516 0 1.0123092173992543
RB516 b516 9 10
X516 64 g516 9 b516 NMOSWRAP
VG517 g517 0 1.3542452871618302
RB517 b517 10 10
X517 64 g517 10 b517 NMOSWRAP
VG518 g518 0 2.1906062056936570
RB518 b518 11 10
X518 64 g518 11 b518 NMOSWRAP
VG519 g519 0 2.6980869075783178
RB519 b519 12 10
X519 64 g519 12 b519 NMOSWRAP
VG520 g520 0 1.8591951345702380
RB520 b520 3 10
X520 65 g520 3 b520 NMOSWRAP
VG521 g521 0 1.2067491273638415
RB521 b521 4 10
X521 65 g521 4 b521 NMOSWRAP
VG522 g522 0 0.5755881450149565
RB522 b522 5 10
X522 65 g522 5 b522 NMOSWRAP
VG523 g523 0 2.2758420724355335
RB523 b523 6 10
X523 65 g523 6 b523 NMOSWRAP
VG524 g524 0 0.5197102587711009
RB524 b524 7 10
X524 65 g524 7 b524 NMOSWRAP
VG525 g525 0 1.4316976745524888
RB525 b525 8 10
X525 65 g525 8 b525 NMOSWRAP
VG526 g526 0 1.8263430364069544
RB526 b526 9 10
X526 65 g526 9 b526 NMOSWRAP
VG527 g527 0 2.8052786544179824
RB527 b527 10 10
X527 65 g527 10 b527 NMOSWRAP
VG528 g528 0 0.7237363625822503
RB528 b528 11 10
X528 65 g528 11 b528 NMOSWRAP
VG529 g529 0 1.5148558049207093
RB529 b529 12 10
X529 65 g529 12 b529 NMOSWRAP
VG530 g530 0 0.5607829992753944
RB530 b530 3 10
X530 66 g530 3 b530 NMOSWRAP
VG531 g531 0 1.3565274608539757
RB531 b531 4 10
X531 66 g531 4 b531 NMOSWRAP
VG532 g532 0 2.0555776470994873
RB532 b532 5 10
X532 66 g532 5 b532 NMOSWRAP
VG533 g533 0 1.1976698705714959
RB533 b533 6 10
X533 66 g533 6 b533 NMOSWRAP
VG534 g534 0 1.0243748741390877
RB534 b534 7 10
X534 66 g534 7 b534 NMOSWRAP
VG535 g535 0 0.7892580833177341
RB535 b535 8 10
X535 66 g535 8 b535 NMOSWRAP
VG536 g536 0 1.9428506100508545
RB536 b536 9 10
X536 66 g536 9 b536 NMOSWRAP
VG537 g537 0 2.2381750147617150
RB537 b537 10 10
X537 66 g537 10 b537 NMOSWRAP
VG538 g538 0 2.1798928514895559
RB538 b538 11 10
X538 66 g538 11 b538 NMOSWRAP
VG539 g539 0 2.8721525518012685
RB539 b539 12 10
X539 66 g539 12 b539 NMOSWRAP
VG540 g540 0 0.5067580347337568
RB540 b540 3 10
X540 67 g540 3 b540 NMOSWRAP
VG541 g541 0 2.1179916347350902
RB541 b541 4 10
X541 67 g541 4 b541 NMOSWRAP
VG542 g542 0 2.0009805927440989
RB542 b542 5 10
X542 67 g542 5 b542 NMOSWRAP
VG543 g543 0 1.9718490249257203
RB543 b543 6 10
X543 67 g543 6 b543 NMOSWRAP
VG544 g544 0 2.9069257996006059
RB544 b544 7 10
X544 67 g544 7 b544 NMOSWRAP
VG545 g545 0 0.5421791834250993
RB545 b545 8 10
X545 67 g545 8 b545 NMOSWRAP
VG546 g546 0 2.2412060767536253
RB546 b546 9 10
X546 67 g546 9 b546 NMOSWRAP
VG547 g547 0 2.5341966242546587
RB547 b547 10 10
X547 67 g547 10 b547 NMOSWRAP
VG548 g548 0 1.7745179915539604
RB548 b548 11 10
X548 67 g548 11 b548 NMOSWRAP
VG549 g549 0 1.3349121739920229
RB549 b549 12 10
X549 67 g549 12 b549 NMOSWRAP
VG550 g550 0 2.4771004080685124
RB550 b550 3 10
X550 68 g550 3 b550 NMOSWRAP
VG551 g551 0 0.7431073140810616
RB551 b551 4 10
X551 68 g551 4 b551 NMOSWRAP
VG552 g552 0 1.6050890943248133
RB552 b552 5 10
X552 68 g552 5 b552 NMOSWRAP
VG553 g553 0 1.7998809364270956
RB553 b553 6 10
X553 68 g553 6 b553 NMOSWRAP
VG554 g554 0 2.2348910273363689
RB554 b554 7 10
X554 68 g554 7 b554 NMOSWRAP
VG555 g555 0 0.7272143300810237
RB555 b555 8 10
X555 68 g555 8 b555 NMOSWRAP
VG556 g556 0 1.0693987538446523
RB556 b556 9 10
X556 68 g556 9 b556 NMOSWRAP
VG557 g557 0 1.5257539067253141
RB557 b557 10 10
X557 68 g557 10 b557 NMOSWRAP
VG558 g558 0 2.0582366825503264
RB558 b558 11 10
X558 68 g558 11 b558 NMOSWRAP
VG559 g559 0 2.7174019530435438
RB559 b559 12 10
X559 68 g559 12 b559 NMOSWRAP
VG560 g560 0 2.0470654206034413
RB560 b560 3 10
X560 69 g560 3 b560 NMOSWRAP
VG561 g561 0 0.8336536773373361
RB561 b561 4 10
X561 69 g561 4 b561 NMOSWRAP
VG562 g562 0 2.9514503319682062
RB562 b562 5 10
X562 69 g562 5 b562 NMOSWRAP
VG563 g563 0 2.6794643368887323
RB563 b563 6 10
X563 69 g563 6 b563 NMOSWRAP
VG564 g564 0 1.7568019028633102
RB564 b564 7 10
X564 69 g564 7 b564 NMOSWRAP
VG565 g565 0 2.8058699544915826
RB565 b565 8 10
X565 69 g565 8 b565 NMOSWRAP
VG566 g566 0 1.8534519843928394
RB566 b566 9 10
X566 69 g566 9 b566 NMOSWRAP
VG567 g567 0 2.8082651697229077
RB567 b567 10 10
X567 69 g567 10 b567 NMOSWRAP
VG568 g568 0 2.5747434215083578
RB568 b568 11 10
X568 69 g568 11 b568 NMOSWRAP
VG569 g569 0 2.9207160257357434
RB569 b569 12 10
X569 69 g569 12 b569 NMOSWRAP
VG570 g570 0 2.7994570269453960
RB570 b570 3 10
X570 70 g570 3 b570 NMOSWRAP
VG571 g571 0 0.5900845435714237
RB571 b571 4 10
X571 70 g571 4 b571 NMOSWRAP
VG572 g572 0 0.9369300104023499
RB572 b572 5 10
X572 70 g572 5 b572 NMOSWRAP
VG573 g573 0 1.4728366927529644
RB573 b573 6 10
X573 70 g573 6 b573 NMOSWRAP
VG574 g574 0 2.8803567432385520
RB574 b574 7 10
X574 70 g574 7 b574 NMOSWRAP
VG575 g575 0 1.2500722986898238
RB575 b575 8 10
X575 70 g575 8 b575 NMOSWRAP
VG576 g576 0 0.9011691097190027
RB576 b576 9 10
X576 70 g576 9 b576 NMOSWRAP
VG577 g577 0 2.7157616652163998
RB577 b577 10 10
X577 70 g577 10 b577 NMOSWRAP
VG578 g578 0 1.6159860387080074
RB578 b578 11 10
X578 70 g578 11 b578 NMOSWRAP
VG579 g579 0 2.7696889858858151
RB579 b579 12 10
X579 70 g579 12 b579 NMOSWRAP
VG580 g580 0 0.9005761658003582
RB580 b580 3 10
X580 71 g580 3 b580 NMOSWRAP
VG581 g581 0 2.1527937787702487
RB581 b581 4 10
X581 71 g581 4 b581 NMOSWRAP
VG582 g582 0 1.6006593820737296
RB582 b582 5 10
X582 71 g582 5 b582 NMOSWRAP
VG583 g583 0 0.6912169225757134
RB583 b583 6 10
X583 71 g583 6 b583 NMOSWRAP
VG584 g584 0 2.2411578616312515
RB584 b584 7 10
X584 71 g584 7 b584 NMOSWRAP
VG585 g585 0 1.1184968888478841
RB585 b585 8 10
X585 71 g585 8 b585 NMOSWRAP
VG586 g586 0 0.5990388064487944
RB586 b586 9 10
X586 71 g586 9 b586 NMOSWRAP
VG587 g587 0 0.6498607456239331
RB587 b587 10 10
X587 71 g587 10 b587 NMOSWRAP
VG588 g588 0 0.6526963426669683
RB588 b588 11 10
X588 71 g588 11 b588 NMOSWRAP
VG589 g589 0 2.7693323937125989
RB589 b589 12 10
X589 71 g589 12 b589 NMOSWRAP
VG590 g590 0 2.3497097945727523
RB590 b590 3 10
X590 72 g590 3 b590 NMOSWRAP
VG591 g591 0 2.7451558930343376
RB591 b591 4 10
X591 72 g591 4 b591 NMOSWRAP
VG592 g592 0 2.1814557782413031
RB592 b592 5 10
X592 72 g592 5 b592 NMOSWRAP
VG593 g593 0 1.8223498225772079
RB593 b593 6 10
X593 72 g593 6 b593 NMOSWRAP
VG594 g594 0 1.2611159108684458
RB594 b594 7 10
X594 72 g594 7 b594 NMOSWRAP
VG595 g595 0 2.9949056283216837
RB595 b595 8 10
X595 72 g595 8 b595 NMOSWRAP
VG596 g596 0 1.4054726473484733
RB596 b596 9 10
X596 72 g596 9 b596 NMOSWRAP
VG597 g597 0 1.6766223730347738
RB597 b597 10 10
X597 72 g597 10 b597 NMOSWRAP
VG598 g598 0 1.4456129373086544
RB598 b598 11 10
X598 72 g598 11 b598 NMOSWRAP
VG599 g599 0 2.9488173233386465
RB599 b599 12 10
X599 72 g599 12 b599 NMOSWRAP
VG600 g600 0 0.9366459634875144
RB600 b600 3 10
X600 73 g600 3 b600 NMOSWRAP
VG601 g601 0 1.3199700022701992
RB601 b601 4 10
X601 73 g601 4 b601 NMOSWRAP
VG602 g602 0 2.2008716650375040
RB602 b602 5 10
X602 73 g602 5 b602 NMOSWRAP
VG603 g603 0 0.6580190458465767
RB603 b603 6 10
X603 73 g603 6 b603 NMOSWRAP
VG604 g604 0 2.0181234350288526
RB604 b604 7 10
X604 73 g604 7 b604 NMOSWRAP
VG605 g605 0 1.6941162571910402
RB605 b605 8 10
X605 73 g605 8 b605 NMOSWRAP
VG606 g606 0 1.2099999419052527
RB606 b606 9 10
X606 73 g606 9 b606 NMOSWRAP
VG607 g607 0 1.0960332023101449
RB607 b607 10 10
X607 73 g607 10 b607 NMOSWRAP
VG608 g608 0 1.7862818582468918
RB608 b608 11 10
X608 73 g608 11 b608 NMOSWRAP
VG609 g609 0 1.4198189513426034
RB609 b609 12 10
X609 73 g609 12 b609 NMOSWRAP
VG610 g610 0 1.6412997281566384
RB610 b610 3 10
X610 74 g610 3 b610 NMOSWRAP
VG611 g611 0 1.3436934544105998
RB611 b611 4 10
X611 74 g611 4 b611 NMOSWRAP
VG612 g612 0 2.9262342339899439
RB612 b612 5 10
X612 74 g612 5 b612 NMOSWRAP
VG613 g613 0 0.8335985793640101
RB613 b613 6 10
X613 74 g613 6 b613 NMOSWRAP
VG614 g614 0 0.7420098829459355
RB614 b614 7 10
X614 74 g614 7 b614 NMOSWRAP
VG615 g615 0 1.3584793219772902
RB615 b615 8 10
X615 74 g615 8 b615 NMOSWRAP
VG616 g616 0 1.9775672521762282
RB616 b616 9 10
X616 74 g616 9 b616 NMOSWRAP
VG617 g617 0 2.1479411796250707
RB617 b617 10 10
X617 74 g617 10 b617 NMOSWRAP
VG618 g618 0 1.4931418679201052
RB618 b618 11 10
X618 74 g618 11 b618 NMOSWRAP
VG619 g619 0 2.9981949848054277
RB619 b619 12 10
X619 74 g619 12 b619 NMOSWRAP
VG620 g620 0 1.3797324904826065
RB620 b620 3 10
X620 75 g620 3 b620 NMOSWRAP
VG621 g621 0 2.3035166698998810
RB621 b621 4 10
X621 75 g621 4 b621 NMOSWRAP
VG622 g622 0 2.0939567363269820
RB622 b622 5 10
X622 75 g622 5 b622 NMOSWRAP
VG623 g623 0 2.5326346581186518
RB623 b623 6 10
X623 75 g623 6 b623 NMOSWRAP
VG624 g624 0 2.9405641586345501
RB624 b624 7 10
X624 75 g624 7 b624 NMOSWRAP
VG625 g625 0 2.7244841411138507
RB625 b625 8 10
X625 75 g625 8 b625 NMOSWRAP
VG626 g626 0 2.4114049358942715
RB626 b626 9 10
X626 75 g626 9 b626 NMOSWRAP
VG627 g627 0 2.2456211945457265
RB627 b627 10 10
X627 75 g627 10 b627 NMOSWRAP
VG628 g628 0 1.3387454241897490
RB628 b628 11 10
X628 75 g628 11 b628 NMOSWRAP
VG629 g629 0 0.8692139455167684
RB629 b629 12 10
X629 75 g629 12 b629 NMOSWRAP
VG630 g630 0 0.6565900076495244
RB630 b630 3 10
X630 76 g630 3 b630 NMOSWRAP
VG631 g631 0 1.1047542605037122
RB631 b631 4 10
X631 76 g631 4 b631 NMOSWRAP
VG632 g632 0 1.5807037029532465
RB632 b632 5 10
X632 76 g632 5 b632 NMOSWRAP
VG633 g633 0 1.8049906840749561
RB633 b633 6 10
X633 76 g633 6 b633 NMOSWRAP
VG634 g634 0 2.4327088851371790
RB634 b634 7 10
X634 76 g634 7 b634 NMOSWRAP
VG635 g635 0 2.8968523076414825
RB635 b635 8 10
X635 76 g635 8 b635 NMOSWRAP
VG636 g636 0 0.7933012009620275
RB636 b636 9 10
X636 76 g636 9 b636 NMOSWRAP
VG637 g637 0 0.7675103504844789
RB637 b637 10 10
X637 76 g637 10 b637 NMOSWRAP
VG638 g638 0 1.9742368075338770
RB638 b638 11 10
X638 76 g638 11 b638 NMOSWRAP
VG639 g639 0 2.3634951848682322
RB639 b639 12 10
X639 76 g639 12 b639 NMOSWRAP
.options TEMP = 27C
.options TNOM = 27C
.options itl1=40 itl2=40 itl4=6 itl5=60
.options gmin=1e-8 reltol=5e-3 abstol=1e-8 vntol=1e-5
.options rshunt=1e9
.op
.end
