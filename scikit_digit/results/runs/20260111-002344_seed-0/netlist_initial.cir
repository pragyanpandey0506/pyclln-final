.title scikit_digits_dense_io_hinge
.include "/home/ma-lab/Desktop/pyclln-final/device_model/nmos_lvl1_ald1106.lib"
.options klu
VMINUS 1 0 0.0000000000000000
VPLUS  2 0 0.4500000000000000
VIN0 13 0 0
VIN1 14 0 0
VIN2 15 0 0
VIN3 16 0 0
VIN4 17 0 0
VIN5 18 0 0
VIN6 19 0 0
VIN7 20 0 0
VIN8 21 0 0
VIN9 22 0 0
VIN10 23 0 0
VIN11 24 0 0
VIN12 25 0 0
VIN13 26 0 0
VIN14 27 0 0
VIN15 28 0 0
VIN16 29 0 0
VIN17 30 0 0
VIN18 31 0 0
VIN19 32 0 0
VIN20 33 0 0
VIN21 34 0 0
VIN22 35 0 0
VIN23 36 0 0
VIN24 37 0 0
VIN25 38 0 0
VIN26 39 0 0
VIN27 40 0 0
VIN28 41 0 0
VIN29 42 0 0
VIN30 43 0 0
VIN31 44 0 0
VIN32 45 0 0
VIN33 46 0 0
VIN34 47 0 0
VIN35 48 0 0
VIN36 49 0 0
VIN37 50 0 0
VIN38 51 0 0
VIN39 52 0 0
VIN40 53 0 0
VIN41 54 0 0
VIN42 55 0 0
VIN43 56 0 0
VIN44 57 0 0
VIN45 58 0 0
VIN46 59 0 0
VIN47 60 0 0
VIN48 61 0 0
VIN49 62 0 0
VIN50 63 0 0
VIN51 64 0 0
VIN52 65 0 0
VIN53 66 0 0
VIN54 67 0 0
VIN55 68 0 0
VIN56 69 0 0
VIN57 70 0 0
VIN58 71 0 0
VIN59 72 0 0
VIN60 73 0 0
VIN61 74 0 0
VIN62 75 0 0
VIN63 76 0 0
RS1 3 77 1e+09
RS2 4 78 1e+09
RS3 5 79 1e+09
RS4 6 80 1e+09
RS5 7 81 1e+09
RS6 8 82 1e+09
RS7 9 83 1e+09
RS8 10 84 1e+09
RS9 11 85 1e+09
RS10 12 86 1e+09
VOUT0 77 0 0
VOUT1 78 0 0
VOUT2 79 0 0
VOUT3 80 0 0
VOUT4 81 0 0
VOUT5 82 0 0
VOUT6 83 0 0
VOUT7 84 0 0
VOUT8 85 0 0
VOUT9 86 0 0
VG0 g0 0 2.0976270078546495
RB0 b0 0 10
X0 13 g0 4 b0 NMOSWRAP
VG1 g1 0 2.4303787327448392
RB1 b1 0 10
X1 14 g1 6 b1 NMOSWRAP
VG2 g2 0 2.2055267521432880
RB2 b2 0 10
X2 15 g2 5 b2 NMOSWRAP
VG3 g3 0 2.0897663659937935
RB3 b3 0 10
X3 15 g3 6 b3 NMOSWRAP
VG4 g4 0 1.8473095986778094
RB4 b4 0 10
X4 15 g4 8 b4 NMOSWRAP
VG5 g5 0 2.2917882261333125
RB5 b5 0 10
X5 15 g5 10 b5 NMOSWRAP
VG6 g6 0 1.8751744225253850
RB6 b6 0 10
X6 15 g6 12 b6 NMOSWRAP
VG7 g7 0 2.7835460015641598
RB7 b7 0 10
X7 16 g7 3 b7 NMOSWRAP
VG8 g8 0 2.9273255210020586
RB8 b8 0 10
X8 16 g8 6 b8 NMOSWRAP
VG9 g9 0 1.7668830376515554
RB9 b9 0 10
X9 16 g9 8 b9 NMOSWRAP
VG10 g10 0 2.5834500761653292
RB10 b10 0 10
X10 16 g10 10 b10 NMOSWRAP
VG11 g11 0 2.0577898395058090
RB11 b11 0 10
X11 17 g11 3 b11 NMOSWRAP
VG12 g12 0 2.1360891221878644
RB12 b12 0 10
X12 17 g12 5 b12 NMOSWRAP
VG13 g13 0 2.8511932765853221
RB13 b13 0 10
X13 17 g13 6 b13 NMOSWRAP
VG14 g14 0 1.1420721163957739
RB14 b14 0 10
X14 17 g14 8 b14 NMOSWRAP
VG15 g15 0 1.1742585994030814
RB15 b15 0 10
X15 17 g15 9 b15 NMOSWRAP
VG16 g16 0 1.0404367948806514
RB16 b16 0 10
X16 17 g16 10 b16 NMOSWRAP
VG17 g17 0 2.6652396910958762
RB17 b17 0 10
X17 18 g17 4 b17 NMOSWRAP
VG18 g18 0 2.5563135018997007
RB18 b18 0 10
X18 18 g18 6 b18 NMOSWRAP
VG19 g19 0 2.7400242964936385
RB19 b19 0 10
X19 18 g19 8 b19 NMOSWRAP
VG20 g20 0 2.9572366844655278
RB20 b20 0 10
X20 18 g20 10 b20 NMOSWRAP
VG21 g21 0 2.5983171284334472
RB21 b21 0 10
X21 18 g21 11 b21 NMOSWRAP
VG22 g22 0 1.9229587245058637
RB22 b22 0 10
X22 19 g22 4 b22 NMOSWRAP
VG23 g23 0 2.5610583525729109
RB23 b23 0 10
X23 19 g23 8 b23 NMOSWRAP
VG24 g24 0 1.2365488517378664
RB24 b24 0 10
X24 19 g24 10 b24 NMOSWRAP
VG25 g25 0 2.2798420426550479
RB25 b25 0 10
X25 19 g25 12 b25 NMOSWRAP
VG26 g26 0 1.2867065748180928
RB26 b26 0 10
X26 21 g26 4 b26 NMOSWRAP
VG27 g27 0 2.8893378340991678
RB27 b27 0 10
X27 22 g27 5 b27 NMOSWRAP
VG28 g28 0 2.0436966435001436
RB28 b28 0 10
X28 22 g28 6 b28 NMOSWRAP
VG29 g29 0 1.8293238799810472
RB29 b29 0 10
X29 22 g29 8 b29 NMOSWRAP
VG30 g30 0 1.5291112242092539
RB30 b30 0 10
X30 23 g30 3 b30 NMOSWRAP
VG31 g31 0 2.5484673788684331
RB31 b31 0 10
X31 23 g31 5 b31 NMOSWRAP
VG32 g32 0 1.9123006644330971
RB32 b32 0 10
X32 23 g32 6 b32 NMOSWRAP
VG33 g33 0 2.1368678977372970
RB33 b33 0 10
X33 23 g33 8 b33 NMOSWRAP
VG34 g34 0 1.0375796008727103
RB34 b34 0 10
X34 23 g34 10 b34 NMOSWRAP
VG35 g35 0 2.2352709941517541
RB35 b35 0 10
X35 23 g35 11 b35 NMOSWRAP
VG36 g36 0 2.2241914454448430
RB36 b36 0 10
X36 23 g36 12 b36 NMOSWRAP
VG37 g37 0 2.2338679937495138
RB37 b37 0 10
X37 24 g37 3 b37 NMOSWRAP
VG38 g38 0 2.8874961570292483
RB38 b38 0 10
X38 24 g38 6 b38 NMOSWRAP
VG39 g39 0 2.3636405982069668
RB39 b39 0 10
X39 24 g39 8 b39 NMOSWRAP
VG40 g40 0 1.7190158011475720
RB40 b40 0 10
X40 24 g40 9 b40 NMOSWRAP
VG41 g41 0 1.8740639075986829
RB41 b41 0 10
X41 24 g41 10 b41 NMOSWRAP
VG42 g42 0 2.3952623918545299
RB42 b42 0 10
X42 25 g42 3 b42 NMOSWRAP
VG43 g43 0 1.1204509432585397
RB43 b43 0 10
X43 25 g43 5 b43 NMOSWRAP
VG44 g44 0 2.3335334308913351
RB44 b44 0 10
X44 25 g44 6 b44 NMOSWRAP
VG45 g45 0 2.3412757392363188
RB45 b45 0 10
X45 25 g45 8 b45 NMOSWRAP
VG46 g46 0 1.4207651221476818
RB46 b46 0 10
X46 25 g46 10 b46 NMOSWRAP
VG47 g47 0 1.2578525953097066
RB47 b47 0 10
X47 26 g47 3 b47 NMOSWRAP
VG48 g48 0 1.6308567018483677
RB48 b48 0 10
X48 26 g48 4 b48 NMOSWRAP
VG49 g49 0 1.7274215418852452
RB49 b49 0 10
X49 26 g49 5 b49 NMOSWRAP
VG50 g50 0 2.1403935408357593
RB50 b50 0 10
X50 26 g50 10 b50 NMOSWRAP
VG51 g51 0 1.8772030269246407
RB51 b51 0 10
X51 26 g51 11 b51 NMOSWRAP
VG52 g52 0 2.9767476761184524
RB52 b52 0 10
X52 27 g52 6 b52 NMOSWRAP
VG53 g53 0 1.2040896214960561
RB53 b53 0 10
X53 27 g53 10 b53 NMOSWRAP
VG54 g54 0 1.4177535121896694
RB54 b54 0 10
X54 27 g54 11 b54 NMOSWRAP
VG55 g55 0 1.3226190357699925
RB55 b55 0 10
X55 29 g55 4 b55 NMOSWRAP
VG56 g56 0 2.3062166509307969
RB56 b56 0 10
X56 30 g56 8 b56 NMOSWRAP
VG57 g57 0 1.5065832050795642
RB57 b57 0 10
X57 30 g57 11 b57 NMOSWRAP
VG58 g58 0 1.9326215457126126
RB58 b58 0 10
X58 30 g58 12 b58 NMOSWRAP
VG59 g59 0 1.4888511840032055
RB59 b59 0 10
X59 31 g59 3 b59 NMOSWRAP
VG60 g60 0 1.3179391672910394
RB60 b60 0 10
X60 31 g60 7 b60 NMOSWRAP
VG61 g61 0 1.2207502823286103
RB61 b61 0 10
X61 31 g61 8 b61 NMOSWRAP
VG62 g62 0 2.3126591789305468
RB62 b62 0 10
X62 31 g62 9 b62 NMOSWRAP
VG63 g63 0 1.2763659026972276
RB63 b63 0 10
X63 31 g63 11 b63 NMOSWRAP
VG64 g64 0 1.3931647233601070
RB64 b64 0 10
X64 31 g64 12 b64 NMOSWRAP
VG65 g65 0 1.7374503413219282
RB65 b65 0 10
X65 32 g65 3 b65 NMOSWRAP
VG66 g66 0 2.6419864596958700
RB66 b66 0 10
X66 32 g66 4 b66 NMOSWRAP
VG67 g67 0 1.1942025515861225
RB67 b67 0 10
X67 32 g67 7 b67 NMOSWRAP
VG68 g68 0 2.6758898149976078
RB68 b68 0 10
X68 32 g68 8 b68 NMOSWRAP
VG69 g69 0 1.1921968157879261
RB69 b69 0 10
X69 32 g69 9 b69 NMOSWRAP
VG70 g70 0 2.9529189300267915
RB70 b70 0 10
X70 32 g70 11 b70 NMOSWRAP
VG71 g71 0 1.9373024032954032
RB71 b71 0 10
X71 33 g71 4 b71 NMOSWRAP
VG72 g72 0 2.9535221763806740
RB72 b72 0 10
X72 33 g72 5 b72 NMOSWRAP
VG73 g73 0 2.2096910394900919
RB73 b73 0 10
X73 33 g73 6 b73 NMOSWRAP
VG74 g74 0 2.4785271587966031
RB74 b74 0 10
X74 33 g74 10 b74 NMOSWRAP
VG75 g75 0 1.0783755845086413
RB75 b75 0 10
X75 34 g75 3 b75 NMOSWRAP
VG76 g76 0 1.5656139251528192
RB76 b76 0 10
X76 34 g76 5 b76 NMOSWRAP
VG77 g77 0 1.2403931224263378
RB77 b77 0 10
X77 34 g77 7 b77 NMOSWRAP
VG78 g78 0 1.5922803950442899
RB78 b78 0 10
X78 34 g78 10 b78 NMOSWRAP
VG79 g79 0 1.2374554379084881
RB79 b79 0 10
X79 34 g79 11 b79 NMOSWRAP
VG80 g80 0 1.6359663587879520
RB80 b80 0 10
X80 34 g80 12 b80 NMOSWRAP
VG81 g81 0 1.8285259890293399
RB81 b81 0 10
X81 35 g81 3 b81 NMOSWRAP
VG82 g82 0 1.1282949926975687
RB82 b82 0 10
X82 35 g82 7 b82 NMOSWRAP
VG83 g83 0 2.3849442387400397
RB83 b83 0 10
X83 35 g83 10 b83 NMOSWRAP
VG84 g84 0 2.1332029084131503
RB84 b84 0 10
X84 35 g84 11 b84 NMOSWRAP
VG85 g85 0 1.5307789818788908
RB85 b85 0 10
X85 37 g85 4 b85 NMOSWRAP
VG86 g86 0 2.0464961069333993
RB86 b86 0 10
X86 38 g86 3 b86 NMOSWRAP
VG87 g87 0 1.1878810215168834
RB87 b87 0 10
X87 38 g87 4 b87 NMOSWRAP
VG88 g88 0 2.1518929911123585
RB88 b88 0 10
X88 38 g88 7 b88 NMOSWRAP
VG89 g89 0 2.8585923951524279
RB89 b89 0 10
X89 38 g89 8 b89 NMOSWRAP
VG90 g90 0 1.6371379049026473
RB90 b90 0 10
X90 39 g90 3 b90 NMOSWRAP
VG91 g91 0 2.3348207599273634
RB91 b91 0 10
X91 39 g91 4 b91 NMOSWRAP
VG92 g92 0 1.2635957248087843
RB92 b92 0 10
X92 39 g92 7 b92 NMOSWRAP
VG93 g93 0 2.4326544082371311
RB93 b93 0 10
X93 39 g93 8 b93 NMOSWRAP
VG94 g94 0 1.5788121858944022
RB94 b94 0 10
X94 39 g94 9 b94 NMOSWRAP
VG95 g95 0 1.3663827240142337
RB95 b95 0 10
X95 39 g95 10 b95 NMOSWRAP
VG96 g96 0 2.1730258696201661
RB96 b96 0 10
X96 39 g96 12 b96 NMOSWRAP
VG97 g97 0 1.0402150923749871
RB97 b97 0 10
X97 40 g97 4 b97 NMOSWRAP
VG98 g98 0 2.6578800584347260
RB98 b98 0 10
X98 40 g98 6 b98 NMOSWRAP
VG99 g99 0 1.0093909523850941
RB99 b99 0 10
X99 40 g99 8 b99 NMOSWRAP
VG100 g100 0 2.3556330735924602
RB100 b100 0 10
X100 40 g100 11 b100 NMOSWRAP
VG101 g101 0 1.5400159463843297
RB101 b101 0 10
X101 40 g101 12 b101 NMOSWRAP
VG102 g102 0 2.4703880442451895
RB102 b102 0 10
X102 41 g102 4 b102 NMOSWRAP
VG103 g103 0 2.9243770902348762
RB103 b103 0 10
X103 41 g103 6 b103 NMOSWRAP
VG104 g104 0 1.4975062870399161
RB104 b104 0 10
X104 41 g104 7 b104 NMOSWRAP
VG105 g105 0 2.1523146688356736
RB105 b105 0 10
X105 41 g105 8 b105 NMOSWRAP
VG106 g106 0 2.1840838625436780
RB106 b106 0 10
X106 41 g106 10 b106 NMOSWRAP
VG107 g107 0 2.1445038115817470
RB107 b107 0 10
X107 41 g107 12 b107 NMOSWRAP
VG108 g108 0 1.4461632652812366
RB108 b108 0 10
X108 42 g108 3 b108 NMOSWRAP
VG109 g109 0 2.9054980230339700
RB109 b109 0 10
X109 42 g109 4 b109 NMOSWRAP
VG110 g110 0 1.8942507572352547
RB110 b110 0 10
X110 42 g110 5 b110 NMOSWRAP
VG111 g111 0 2.6928173449422559
RB111 b111 0 10
X111 42 g111 7 b111 NMOSWRAP
VG112 g112 0 2.3989585506350086
RB112 b112 0 10
X112 42 g112 10 b112 NMOSWRAP
VG113 g113 0 1.5948739017102673
RB113 b113 0 10
X113 42 g113 12 b113 NMOSWRAP
VG114 g114 0 2.6275956394049542
RB114 b114 0 10
X114 43 g114 3 b114 NMOSWRAP
VG115 g115 0 1.7930114816939693
RB115 b115 0 10
X115 43 g115 7 b115 NMOSWRAP
VG116 g116 0 2.7622063942223232
RB116 b116 0 10
X116 43 g116 10 b116 NMOSWRAP
VG117 g117 0 2.1625457452717174
RB117 b117 0 10
X117 43 g117 12 b117 NMOSWRAP
VG118 g118 0 2.7634707237097054
RB118 b118 0 10
X118 44 g118 4 b118 NMOSWRAP
VG119 g119 0 2.3850631801555320
RB119 b119 0 10
X119 45 g119 4 b119 NMOSWRAP
VG120 g120 0 2.4505085596392808
RB120 b120 0 10
X120 46 g120 3 b120 NMOSWRAP
VG121 g121 0 2.0026487638534043
RB121 b121 0 10
X121 46 g121 4 b121 NMOSWRAP
VG122 g122 0 2.9121672694464475
RB122 b122 0 10
X122 46 g122 7 b122 NMOSWRAP
VG123 g123 0 2.2879803984592746
RB123 b123 0 10
X123 46 g123 9 b123 NMOSWRAP
VG124 g124 0 1.8477100971163594
RB124 b124 0 10
X124 47 g124 3 b124 NMOSWRAP
VG125 g125 0 2.2127864282558489
RB125 b125 0 10
X125 47 g125 4 b125 NMOSWRAP
VG126 g126 0 1.0383863966186671
RB126 b126 0 10
X126 47 g126 7 b126 NMOSWRAP
VG127 g127 0 1.6031496333490987
RB127 b127 0 10
X127 47 g127 8 b127 NMOSWRAP
VG128 g128 0 2.3203470749853699
RB128 b128 0 10
X128 47 g128 9 b128 NMOSWRAP
VG129 g129 0 1.5801552144208881
RB129 b129 0 10
X129 47 g129 10 b129 NMOSWRAP
VG130 g130 0 2.2360308579976831
RB130 b130 0 10
X130 47 g130 12 b130 NMOSWRAP
VG131 g131 0 1.8575374018915323
RB131 b131 0 10
X131 48 g131 4 b131 NMOSWRAP
VG132 g132 0 1.2709481284449005
RB132 b132 0 10
X132 48 g132 8 b132 NMOSWRAP
VG133 g133 0 1.5965646519120615
RB133 b133 0 10
X133 48 g133 9 b133 NMOSWRAP
VG134 g134 0 2.1399298214025295
RB134 b134 0 10
X134 48 g134 10 b134 NMOSWRAP
VG135 g135 0 2.1817455224963465
RB135 b135 0 10
X135 48 g135 11 b135 NMOSWRAP
VG136 g136 0 2.1486504976991574
RB136 b136 0 10
X136 48 g136 12 b136 NMOSWRAP
VG137 g137 0 2.3064016397142675
RB137 b137 0 10
X137 49 g137 4 b137 NMOSWRAP
VG138 g138 0 2.3042065400033778
RB138 b138 0 10
X138 49 g138 6 b138 NMOSWRAP
VG139 g139 0 1.8628368708679479
RB139 b139 0 10
X139 49 g139 7 b139 NMOSWRAP
VG140 g140 0 2.7930931917021260
RB140 b140 0 10
X140 49 g140 8 b140 NMOSWRAP
VG141 g141 0 1.7351237400957931
RB141 b141 0 10
X141 49 g141 9 b141 NMOSWRAP
VG142 g142 0 1.8717298505312536
RB142 b142 0 10
X142 49 g142 10 b142 NMOSWRAP
VG143 g143 0 2.7838467100313444
RB143 b143 0 10
X143 49 g143 11 b143 NMOSWRAP
VG144 g144 0 2.6123879780921717
RB144 b144 0 10
X144 50 g144 3 b144 NMOSWRAP
VG145 g145 0 2.4077771670807326
RB145 b145 0 10
X145 50 g145 4 b145 NMOSWRAP
VG146 g146 0 1.2004537746246022
RB146 b146 0 10
X146 50 g146 6 b146 NMOSWRAP
VG147 g147 0 2.8389652274893473
RB147 b147 0 10
X147 50 g147 7 b147 NMOSWRAP
VG148 g148 0 2.4284825990982228
RB148 b148 0 10
X148 50 g148 8 b148 NMOSWRAP
VG149 g149 0 2.9976940131357330
RB149 b149 0 10
X149 50 g149 9 b149 NMOSWRAP
VG150 g150 0 1.2988966093159875
RB150 b150 0 10
X150 50 g150 10 b150 NMOSWRAP
VG151 g151 0 2.7362521147364287
RB151 b151 0 10
X151 51 g151 3 b151 NMOSWRAP
VG152 g152 0 1.3249858693527496
RB152 b152 0 10
X152 51 g152 7 b152 NMOSWRAP
VG153 g153 0 2.2311191285676886
RB153 b153 0 10
X153 51 g153 10 b153 NMOSWRAP
VG154 g154 0 1.2476399656988830
RB154 b154 0 10
X154 51 g154 12 b154 NMOSWRAP
VG155 g155 0 2.6960164586444688
RB155 b155 0 10
X155 52 g155 4 b155 NMOSWRAP
VG156 g156 0 2.6146379174500214
RB156 b156 0 10
X156 53 g156 4 b156 NMOSWRAP
VG157 g157 0 2.1382014772291864
RB157 b157 0 10
X157 54 g157 7 b157 NMOSWRAP
VG158 g158 0 1.8143665944519993
RB158 b158 0 10
X158 54 g158 11 b158 NMOSWRAP
VG159 g159 0 1.1383339909102761
RB159 b159 0 10
X159 55 g159 3 b159 NMOSWRAP
VG160 g160 0 2.3948575462891273
RB160 b160 0 10
X160 55 g160 5 b160 NMOSWRAP
VG161 g161 0 1.9070853653561377
RB161 b161 0 10
X161 55 g161 7 b161 NMOSWRAP
VG162 g162 0 2.4441111989406958
RB162 b162 0 10
X162 55 g162 9 b162 NMOSWRAP
VG163 g163 0 2.7327646518572584
RB163 b163 0 10
X163 55 g163 11 b163 NMOSWRAP
VG164 g164 0 2.9510430100057716
RB164 b164 0 10
X164 56 g164 4 b164 NMOSWRAP
VG165 g165 0 2.7116066847852220
RB165 b165 0 10
X165 56 g165 5 b165 NMOSWRAP
VG166 g166 0 1.0234281683700039
RB166 b166 0 10
X166 56 g166 7 b166 NMOSWRAP
VG167 g167 0 1.7199561289567278
RB167 b167 0 10
X167 56 g167 8 b167 NMOSWRAP
VG168 g168 0 2.4599811248481158
RB168 b168 0 10
X168 56 g168 9 b168 NMOSWRAP
VG169 g169 0 1.3432593545228810
RB169 b169 0 10
X169 56 g169 10 b169 NMOSWRAP
VG170 g170 0 2.0420732124082583
RB170 b170 0 10
X170 56 g170 11 b170 NMOSWRAP
VG171 g171 0 1.1086759766785073
RB171 b171 0 10
X171 57 g171 4 b171 NMOSWRAP
VG172 g172 0 1.3999930497928001
RB172 b172 0 10
X172 57 g172 6 b172 NMOSWRAP
VG173 g173 0 1.0370435889212279
RB173 b173 0 10
X173 57 g173 7 b173 NMOSWRAP
VG174 g174 0 2.5873954067148413
RB174 b174 0 10
X174 57 g174 9 b174 NMOSWRAP
VG175 g175 0 1.4478493761207603
RB175 b175 0 10
X175 57 g175 10 b175 NMOSWRAP
VG176 g176 0 1.6907033613938054
RB176 b176 0 10
X176 57 g176 11 b176 NMOSWRAP
VG177 g177 0 2.8561625869311817
RB177 b177 0 10
X177 58 g177 3 b177 NMOSWRAP
VG178 g178 0 2.4088288038470655
RB178 b178 0 10
X178 58 g178 6 b178 NMOSWRAP
VG179 g179 0 1.0636778590626157
RB179 b179 0 10
X179 58 g179 7 b179 NMOSWRAP
VG180 g180 0 1.3293883129958255
RB180 b180 0 10
X180 58 g180 8 b180 NMOSWRAP
VG181 g181 0 2.2429568029995268
RB181 b181 0 10
X181 58 g181 11 b181 NMOSWRAP
VG182 g182 0 2.1544571772083350
RB182 b182 0 10
X182 59 g182 6 b182 NMOSWRAP
VG183 g183 0 1.4757856427490172
RB183 b183 0 10
X183 59 g183 8 b183 NMOSWRAP
VG184 g184 0 2.8684279958495873
RB184 b184 0 10
X184 59 g184 9 b184 NMOSWRAP
VG185 g185 0 2.2279319119317922
RB185 b185 0 10
X185 59 g185 12 b185 NMOSWRAP
VG186 g186 0 2.0712656060499164
RB186 b186 0 10
X186 60 g186 4 b186 NMOSWRAP
VG187 g187 0 2.1798199527091420
RB187 b187 0 10
X187 61 g187 4 b187 NMOSWRAP
VG188 g188 0 2.4602440590335393
RB188 b188 0 10
X188 62 g188 5 b188 NMOSWRAP
VG189 g189 0 1.6238899909592037
RB189 b189 0 10
X189 62 g189 6 b189 NMOSWRAP
VG190 g190 0 1.7964421244321838
RB190 b190 0 10
X190 62 g190 7 b190 NMOSWRAP
VG191 g191 0 1.4196874979502443
RB191 b191 0 10
X191 63 g191 3 b191 NMOSWRAP
VG192 g192 0 1.3723860117606723
RB192 b192 0 10
X192 63 g192 5 b192 NMOSWRAP
VG193 g193 0 2.8887447799678672
RB193 b193 0 10
X193 63 g193 6 b193 NMOSWRAP
VG194 g194 0 2.4791015900985753
RB194 b194 0 10
X194 63 g194 9 b194 NMOSWRAP
VG195 g195 0 1.9809176172351342
RB195 b195 0 10
X195 63 g195 11 b195 NMOSWRAP
VG196 g196 0 1.4548292559466465
RB196 b196 0 10
X196 63 g196 12 b196 NMOSWRAP
VG197 g197 0 1.5087129635407859
RB197 b197 0 10
X197 64 g197 3 b197 NMOSWRAP
VG198 g198 0 1.1160583206477512
RB198 b198 0 10
X198 64 g198 4 b198 NMOSWRAP
VG199 g199 0 1.8688332511162415
RB199 b199 0 10
X199 64 g199 5 b199 NMOSWRAP
VG200 g200 0 1.6235917639882051
RB200 b200 0 10
X200 64 g200 9 b200 NMOSWRAP
VG201 g201 0 2.3926869776309188
RB201 b201 0 10
X201 64 g201 10 b201 NMOSWRAP
VG202 g202 0 1.7555036785849618
RB202 b202 0 10
X202 65 g202 3 b202 NMOSWRAP
VG203 g203 0 1.3592073551192696
RB203 b203 0 10
X203 65 g203 4 b203 NMOSWRAP
VG204 g204 0 1.0493574567826625
RB204 b204 0 10
X204 65 g204 5 b204 NMOSWRAP
VG205 g205 0 1.1344992629264972
RB205 b205 0 10
X205 65 g205 6 b205 NMOSWRAP
VG206 g206 0 2.3587855469971348
RB206 b206 0 10
X206 65 g206 7 b206 NMOSWRAP
VG207 g207 0 1.9073936891120906
RB207 b207 0 10
X207 65 g207 8 b207 NMOSWRAP
VG208 g208 0 2.0731584222174444
RB208 b208 0 10
X208 66 g208 3 b208 NMOSWRAP
VG209 g209 0 2.7933425860806844
RB209 b209 0 10
X209 66 g209 5 b209 NMOSWRAP
VG210 g210 0 2.9806778947934087
RB210 b210 0 10
X210 66 g210 6 b210 NMOSWRAP
VG211 g211 0 1.4337939687969479
RB211 b211 0 10
X211 66 g211 8 b211 NMOSWRAP
VG212 g212 0 2.3261564062002016
RB212 b212 0 10
X212 66 g212 9 b212 NMOSWRAP
VG213 g213 0 1.5266447534743013
RB213 b213 0 10
X213 66 g213 11 b213 NMOSWRAP
VG214 g214 0 1.0413019989314574
RB214 b214 0 10
X214 67 g214 6 b214 NMOSWRAP
VG215 g215 0 2.5167573076722829
RB215 b215 0 10
X215 67 g215 9 b215 NMOSWRAP
VG216 g216 0 1.6400343016449357
RB216 b216 0 10
X216 67 g216 12 b216 NMOSWRAP
VG217 g217 0 1.7669277883437959
RB217 b217 0 10
X217 68 g217 4 b217 NMOSWRAP
VG218 g218 0 2.1766342271072112
RB218 b218 0 10
X218 69 g218 4 b218 NMOSWRAP
VG219 g219 0 2.6620969104723811
RB219 b219 0 10
X219 71 g219 5 b219 NMOSWRAP
VG220 g220 0 2.2579636871822975
RB220 b220 0 10
X220 71 g220 6 b220 NMOSWRAP
VG221 g221 0 2.7453013108947903
RB221 b221 0 10
X221 71 g221 8 b221 NMOSWRAP
VG222 g222 0 1.5470840696312715
RB222 b222 0 10
X222 71 g222 10 b222 NMOSWRAP
VG223 g223 0 2.5960936678251274
RB223 b223 0 10
X223 71 g223 12 b223 NMOSWRAP
VG224 g224 0 1.3712718886119044
RB224 b224 0 10
X224 72 g224 3 b224 NMOSWRAP
VG225 g225 0 2.9055833139438891
RB225 b225 0 10
X225 72 g225 6 b225 NMOSWRAP
VG226 g226 0 2.3749765527756308
RB226 b226 0 10
X226 72 g226 8 b226 NMOSWRAP
VG227 g227 0 1.4310153542271169
RB227 b227 0 10
X227 72 g227 11 b227 NMOSWRAP
VG228 g228 0 2.8947411809778485
RB228 b228 0 10
X228 73 g228 3 b228 NMOSWRAP
VG229 g229 0 2.4617116135403156
RB229 b229 0 10
X229 73 g229 6 b229 NMOSWRAP
VG230 g230 0 1.5078832851900517
RB230 b230 0 10
X230 73 g230 7 b230 NMOSWRAP
VG231 g231 0 1.4266239547349640
RB231 b231 0 10
X231 73 g231 9 b231 NMOSWRAP
VG232 g232 0 2.0364014278613265
RB232 b232 0 10
X232 73 g232 11 b232 NMOSWRAP
VG233 g233 0 1.0513254361090631
RB233 b233 0 10
X233 73 g233 12 b233 NMOSWRAP
VG234 g234 0 1.4149401508822188
RB234 b234 0 10
X234 74 g234 4 b234 NMOSWRAP
VG235 g235 0 1.8493709375030125
RB235 b235 0 10
X235 74 g235 5 b235 NMOSWRAP
VG236 g236 0 1.7483399606684511
RB236 b236 0 10
X236 74 g236 6 b236 NMOSWRAP
VG237 g237 0 1.9271508487296214
RB237 b237 0 10
X237 74 g237 9 b237 NMOSWRAP
VG238 g238 0 1.5552574125894638
RB238 b238 0 10
X238 74 g238 11 b238 NMOSWRAP
VG239 g239 0 2.1735686929163376
RB239 b239 0 10
X239 74 g239 12 b239 NMOSWRAP
VG240 g240 0 2.7277112118464628
RB240 b240 0 10
X240 75 g240 4 b240 NMOSWRAP
VG241 g241 0 1.2350637119240662
RB241 b241 0 10
X241 75 g241 5 b241 NMOSWRAP
VG242 g242 0 2.0347582143082281
RB242 b242 0 10
X242 76 g242 4 b242 NMOSWRAP
VG243 g243 0 1.2641362126903066
RB243 b243 0 10
X243 76 g243 5 b243 NMOSWRAP
.options TEMP = 27C
.options TNOM = 27C
.options itl1=40 itl2=40 itl4=6 itl5=60
.options gmin=1e-8 reltol=5e-3 abstol=1e-8 vntol=1e-5
.options rshunt=1e9
.op
.end
