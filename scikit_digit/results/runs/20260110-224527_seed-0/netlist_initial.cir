.title scikit_digits_dense_io_hinge
.include "/home/ma-lab/Desktop/pyclln-final/device_model/nmos_lvl1_ald1106.lib"
.options klu
VMINUS 1 0 0.0000000000000000
VPLUS  2 0 0.4500000000000000
VIN0 13 0 0
VIN1 14 0 0
VIN2 15 0 0
VIN3 16 0 0
VIN4 17 0 0
VIN5 18 0 0
VIN6 19 0 0
VIN7 20 0 0
VIN8 21 0 0
VIN9 22 0 0
VIN10 23 0 0
VIN11 24 0 0
VIN12 25 0 0
VIN13 26 0 0
VIN14 27 0 0
VIN15 28 0 0
VIN16 29 0 0
VIN17 30 0 0
VIN18 31 0 0
VIN19 32 0 0
VIN20 33 0 0
VIN21 34 0 0
VIN22 35 0 0
VIN23 36 0 0
VIN24 37 0 0
VIN25 38 0 0
VIN26 39 0 0
VIN27 40 0 0
VIN28 41 0 0
VIN29 42 0 0
VIN30 43 0 0
VIN31 44 0 0
VIN32 45 0 0
VIN33 46 0 0
VIN34 47 0 0
VIN35 48 0 0
VIN36 49 0 0
VIN37 50 0 0
VIN38 51 0 0
VIN39 52 0 0
VIN40 53 0 0
VIN41 54 0 0
VIN42 55 0 0
VIN43 56 0 0
VIN44 57 0 0
VIN45 58 0 0
VIN46 59 0 0
VIN47 60 0 0
VIN48 61 0 0
VIN49 62 0 0
VIN50 63 0 0
VIN51 64 0 0
VIN52 65 0 0
VIN53 66 0 0
VIN54 67 0 0
VIN55 68 0 0
VIN56 69 0 0
VIN57 70 0 0
VIN58 71 0 0
VIN59 72 0 0
VIN60 73 0 0
VIN61 74 0 0
VIN62 75 0 0
VIN63 76 0 0
RS1 3 77 1e+09
RS2 4 78 1e+09
RS3 5 79 1e+09
RS4 6 80 1e+09
RS5 7 81 1e+09
RS6 8 82 1e+09
RS7 9 83 1e+09
RS8 10 84 1e+09
RS9 11 85 1e+09
RS10 12 86 1e+09
VOUT0 77 0 0
VOUT1 78 0 0
VOUT2 79 0 0
VOUT3 80 0 0
VOUT4 81 0 0
VOUT5 82 0 0
VOUT6 83 0 0
VOUT7 84 0 0
VOUT8 85 0 0
VOUT9 86 0 0
VG0 g0 0 2.0976270078546495
RB0 b0 0 10
X0 13 g0 3 b0 NMOSWRAP
VG1 g1 0 2.4303787327448392
RB1 b1 0 10
X1 13 g1 3 b1 NMOSWRAP
VG2 g2 0 2.2055267521432880
RB2 b2 0 10
X2 13 g2 3 b2 NMOSWRAP
VG3 g3 0 2.0897663659937935
RB3 b3 0 10
X3 13 g3 4 b3 NMOSWRAP
VG4 g4 0 1.8473095986778094
RB4 b4 0 10
X4 13 g4 4 b4 NMOSWRAP
VG5 g5 0 2.2917882261333125
RB5 b5 0 10
X5 13 g5 4 b5 NMOSWRAP
VG6 g6 0 1.8751744225253850
RB6 b6 0 10
X6 13 g6 5 b6 NMOSWRAP
VG7 g7 0 2.7835460015641598
RB7 b7 0 10
X7 13 g7 5 b7 NMOSWRAP
VG8 g8 0 2.9273255210020586
RB8 b8 0 10
X8 13 g8 5 b8 NMOSWRAP
VG9 g9 0 1.7668830376515554
RB9 b9 0 10
X9 13 g9 6 b9 NMOSWRAP
VG10 g10 0 2.5834500761653292
RB10 b10 0 10
X10 13 g10 6 b10 NMOSWRAP
VG11 g11 0 2.0577898395058090
RB11 b11 0 10
X11 13 g11 6 b11 NMOSWRAP
VG12 g12 0 2.1360891221878644
RB12 b12 0 10
X12 13 g12 7 b12 NMOSWRAP
VG13 g13 0 2.8511932765853221
RB13 b13 0 10
X13 13 g13 7 b13 NMOSWRAP
VG14 g14 0 1.1420721163957739
RB14 b14 0 10
X14 13 g14 7 b14 NMOSWRAP
VG15 g15 0 1.1742585994030814
RB15 b15 0 10
X15 13 g15 8 b15 NMOSWRAP
VG16 g16 0 1.0404367948806514
RB16 b16 0 10
X16 13 g16 8 b16 NMOSWRAP
VG17 g17 0 2.6652396910958762
RB17 b17 0 10
X17 13 g17 8 b17 NMOSWRAP
VG18 g18 0 2.5563135018997007
RB18 b18 0 10
X18 13 g18 9 b18 NMOSWRAP
VG19 g19 0 2.7400242964936385
RB19 b19 0 10
X19 13 g19 9 b19 NMOSWRAP
VG20 g20 0 2.9572366844655278
RB20 b20 0 10
X20 13 g20 9 b20 NMOSWRAP
VG21 g21 0 2.5983171284334472
RB21 b21 0 10
X21 13 g21 10 b21 NMOSWRAP
VG22 g22 0 1.9229587245058637
RB22 b22 0 10
X22 13 g22 10 b22 NMOSWRAP
VG23 g23 0 2.5610583525729109
RB23 b23 0 10
X23 13 g23 10 b23 NMOSWRAP
VG24 g24 0 1.2365488517378664
RB24 b24 0 10
X24 13 g24 11 b24 NMOSWRAP
VG25 g25 0 2.2798420426550479
RB25 b25 0 10
X25 13 g25 11 b25 NMOSWRAP
VG26 g26 0 1.2867065748180928
RB26 b26 0 10
X26 13 g26 11 b26 NMOSWRAP
VG27 g27 0 2.8893378340991678
RB27 b27 0 10
X27 13 g27 12 b27 NMOSWRAP
VG28 g28 0 2.0436966435001436
RB28 b28 0 10
X28 13 g28 12 b28 NMOSWRAP
VG29 g29 0 1.8293238799810472
RB29 b29 0 10
X29 13 g29 12 b29 NMOSWRAP
VG30 g30 0 1.5291112242092539
RB30 b30 0 10
X30 14 g30 3 b30 NMOSWRAP
VG31 g31 0 2.5484673788684331
RB31 b31 0 10
X31 14 g31 3 b31 NMOSWRAP
VG32 g32 0 1.9123006644330971
RB32 b32 0 10
X32 14 g32 3 b32 NMOSWRAP
VG33 g33 0 2.1368678977372970
RB33 b33 0 10
X33 14 g33 4 b33 NMOSWRAP
VG34 g34 0 1.0375796008727103
RB34 b34 0 10
X34 14 g34 4 b34 NMOSWRAP
VG35 g35 0 2.2352709941517541
RB35 b35 0 10
X35 14 g35 4 b35 NMOSWRAP
VG36 g36 0 2.2241914454448430
RB36 b36 0 10
X36 14 g36 5 b36 NMOSWRAP
VG37 g37 0 2.2338679937495138
RB37 b37 0 10
X37 14 g37 5 b37 NMOSWRAP
VG38 g38 0 2.8874961570292483
RB38 b38 0 10
X38 14 g38 5 b38 NMOSWRAP
VG39 g39 0 2.3636405982069668
RB39 b39 0 10
X39 14 g39 6 b39 NMOSWRAP
VG40 g40 0 1.7190158011475720
RB40 b40 0 10
X40 14 g40 6 b40 NMOSWRAP
VG41 g41 0 1.8740639075986829
RB41 b41 0 10
X41 14 g41 6 b41 NMOSWRAP
VG42 g42 0 2.3952623918545299
RB42 b42 0 10
X42 14 g42 7 b42 NMOSWRAP
VG43 g43 0 1.1204509432585397
RB43 b43 0 10
X43 14 g43 7 b43 NMOSWRAP
VG44 g44 0 2.3335334308913351
RB44 b44 0 10
X44 14 g44 7 b44 NMOSWRAP
VG45 g45 0 2.3412757392363188
RB45 b45 0 10
X45 14 g45 8 b45 NMOSWRAP
VG46 g46 0 1.4207651221476818
RB46 b46 0 10
X46 14 g46 8 b46 NMOSWRAP
VG47 g47 0 1.2578525953097066
RB47 b47 0 10
X47 14 g47 8 b47 NMOSWRAP
VG48 g48 0 1.6308567018483677
RB48 b48 0 10
X48 14 g48 9 b48 NMOSWRAP
VG49 g49 0 1.7274215418852452
RB49 b49 0 10
X49 14 g49 9 b49 NMOSWRAP
VG50 g50 0 2.1403935408357593
RB50 b50 0 10
X50 14 g50 9 b50 NMOSWRAP
VG51 g51 0 1.8772030269246407
RB51 b51 0 10
X51 14 g51 10 b51 NMOSWRAP
VG52 g52 0 2.9767476761184524
RB52 b52 0 10
X52 14 g52 10 b52 NMOSWRAP
VG53 g53 0 1.2040896214960561
RB53 b53 0 10
X53 14 g53 10 b53 NMOSWRAP
VG54 g54 0 1.4177535121896694
RB54 b54 0 10
X54 14 g54 11 b54 NMOSWRAP
VG55 g55 0 1.3226190357699925
RB55 b55 0 10
X55 14 g55 11 b55 NMOSWRAP
VG56 g56 0 2.3062166509307969
RB56 b56 0 10
X56 14 g56 11 b56 NMOSWRAP
VG57 g57 0 1.5065832050795642
RB57 b57 0 10
X57 14 g57 12 b57 NMOSWRAP
VG58 g58 0 1.9326215457126126
RB58 b58 0 10
X58 14 g58 12 b58 NMOSWRAP
VG59 g59 0 1.4888511840032055
RB59 b59 0 10
X59 14 g59 12 b59 NMOSWRAP
VG60 g60 0 1.3179391672910394
RB60 b60 0 10
X60 15 g60 3 b60 NMOSWRAP
VG61 g61 0 1.2207502823286103
RB61 b61 0 10
X61 15 g61 3 b61 NMOSWRAP
VG62 g62 0 2.3126591789305468
RB62 b62 0 10
X62 15 g62 3 b62 NMOSWRAP
VG63 g63 0 1.2763659026972276
RB63 b63 0 10
X63 15 g63 4 b63 NMOSWRAP
VG64 g64 0 1.3931647233601070
RB64 b64 0 10
X64 15 g64 4 b64 NMOSWRAP
VG65 g65 0 1.7374503413219282
RB65 b65 0 10
X65 15 g65 4 b65 NMOSWRAP
VG66 g66 0 2.6419864596958700
RB66 b66 0 10
X66 15 g66 5 b66 NMOSWRAP
VG67 g67 0 1.1942025515861225
RB67 b67 0 10
X67 15 g67 5 b67 NMOSWRAP
VG68 g68 0 2.6758898149976078
RB68 b68 0 10
X68 15 g68 5 b68 NMOSWRAP
VG69 g69 0 1.1921968157879261
RB69 b69 0 10
X69 15 g69 6 b69 NMOSWRAP
VG70 g70 0 2.9529189300267915
RB70 b70 0 10
X70 15 g70 6 b70 NMOSWRAP
VG71 g71 0 1.9373024032954032
RB71 b71 0 10
X71 15 g71 6 b71 NMOSWRAP
VG72 g72 0 2.9535221763806740
RB72 b72 0 10
X72 15 g72 7 b72 NMOSWRAP
VG73 g73 0 2.2096910394900919
RB73 b73 0 10
X73 15 g73 7 b73 NMOSWRAP
VG74 g74 0 2.4785271587966031
RB74 b74 0 10
X74 15 g74 7 b74 NMOSWRAP
VG75 g75 0 1.0783755845086413
RB75 b75 0 10
X75 15 g75 8 b75 NMOSWRAP
VG76 g76 0 1.5656139251528192
RB76 b76 0 10
X76 15 g76 8 b76 NMOSWRAP
VG77 g77 0 1.2403931224263378
RB77 b77 0 10
X77 15 g77 8 b77 NMOSWRAP
VG78 g78 0 1.5922803950442899
RB78 b78 0 10
X78 15 g78 9 b78 NMOSWRAP
VG79 g79 0 1.2374554379084881
RB79 b79 0 10
X79 15 g79 9 b79 NMOSWRAP
VG80 g80 0 1.6359663587879520
RB80 b80 0 10
X80 15 g80 9 b80 NMOSWRAP
VG81 g81 0 1.8285259890293399
RB81 b81 0 10
X81 15 g81 10 b81 NMOSWRAP
VG82 g82 0 1.1282949926975687
RB82 b82 0 10
X82 15 g82 10 b82 NMOSWRAP
VG83 g83 0 2.3849442387400397
RB83 b83 0 10
X83 15 g83 10 b83 NMOSWRAP
VG84 g84 0 2.1332029084131503
RB84 b84 0 10
X84 15 g84 11 b84 NMOSWRAP
VG85 g85 0 1.5307789818788908
RB85 b85 0 10
X85 15 g85 11 b85 NMOSWRAP
VG86 g86 0 2.0464961069333993
RB86 b86 0 10
X86 15 g86 11 b86 NMOSWRAP
VG87 g87 0 1.1878810215168834
RB87 b87 0 10
X87 15 g87 12 b87 NMOSWRAP
VG88 g88 0 2.1518929911123585
RB88 b88 0 10
X88 15 g88 12 b88 NMOSWRAP
VG89 g89 0 2.8585923951524279
RB89 b89 0 10
X89 15 g89 12 b89 NMOSWRAP
VG90 g90 0 1.6371379049026473
RB90 b90 0 10
X90 16 g90 3 b90 NMOSWRAP
VG91 g91 0 2.3348207599273634
RB91 b91 0 10
X91 16 g91 3 b91 NMOSWRAP
VG92 g92 0 1.2635957248087843
RB92 b92 0 10
X92 16 g92 3 b92 NMOSWRAP
VG93 g93 0 2.4326544082371311
RB93 b93 0 10
X93 16 g93 4 b93 NMOSWRAP
VG94 g94 0 1.5788121858944022
RB94 b94 0 10
X94 16 g94 4 b94 NMOSWRAP
VG95 g95 0 1.3663827240142337
RB95 b95 0 10
X95 16 g95 4 b95 NMOSWRAP
VG96 g96 0 2.1730258696201661
RB96 b96 0 10
X96 16 g96 5 b96 NMOSWRAP
VG97 g97 0 1.0402150923749871
RB97 b97 0 10
X97 16 g97 5 b97 NMOSWRAP
VG98 g98 0 2.6578800584347260
RB98 b98 0 10
X98 16 g98 5 b98 NMOSWRAP
VG99 g99 0 1.0093909523850941
RB99 b99 0 10
X99 16 g99 6 b99 NMOSWRAP
VG100 g100 0 2.3556330735924602
RB100 b100 0 10
X100 16 g100 6 b100 NMOSWRAP
VG101 g101 0 1.5400159463843297
RB101 b101 0 10
X101 16 g101 6 b101 NMOSWRAP
VG102 g102 0 2.4703880442451895
RB102 b102 0 10
X102 16 g102 7 b102 NMOSWRAP
VG103 g103 0 2.9243770902348762
RB103 b103 0 10
X103 16 g103 7 b103 NMOSWRAP
VG104 g104 0 1.4975062870399161
RB104 b104 0 10
X104 16 g104 7 b104 NMOSWRAP
VG105 g105 0 2.1523146688356736
RB105 b105 0 10
X105 16 g105 8 b105 NMOSWRAP
VG106 g106 0 2.1840838625436780
RB106 b106 0 10
X106 16 g106 8 b106 NMOSWRAP
VG107 g107 0 2.1445038115817470
RB107 b107 0 10
X107 16 g107 8 b107 NMOSWRAP
VG108 g108 0 1.4461632652812366
RB108 b108 0 10
X108 16 g108 9 b108 NMOSWRAP
VG109 g109 0 2.9054980230339700
RB109 b109 0 10
X109 16 g109 9 b109 NMOSWRAP
VG110 g110 0 1.8942507572352547
RB110 b110 0 10
X110 16 g110 9 b110 NMOSWRAP
VG111 g111 0 2.6928173449422559
RB111 b111 0 10
X111 16 g111 10 b111 NMOSWRAP
VG112 g112 0 2.3989585506350086
RB112 b112 0 10
X112 16 g112 10 b112 NMOSWRAP
VG113 g113 0 1.5948739017102673
RB113 b113 0 10
X113 16 g113 10 b113 NMOSWRAP
VG114 g114 0 2.6275956394049542
RB114 b114 0 10
X114 16 g114 11 b114 NMOSWRAP
VG115 g115 0 1.7930114816939693
RB115 b115 0 10
X115 16 g115 11 b115 NMOSWRAP
VG116 g116 0 2.7622063942223232
RB116 b116 0 10
X116 16 g116 11 b116 NMOSWRAP
VG117 g117 0 2.1625457452717174
RB117 b117 0 10
X117 16 g117 12 b117 NMOSWRAP
VG118 g118 0 2.7634707237097054
RB118 b118 0 10
X118 16 g118 12 b118 NMOSWRAP
VG119 g119 0 2.3850631801555320
RB119 b119 0 10
X119 16 g119 12 b119 NMOSWRAP
VG120 g120 0 2.4505085596392808
RB120 b120 0 10
X120 17 g120 3 b120 NMOSWRAP
VG121 g121 0 2.0026487638534043
RB121 b121 0 10
X121 17 g121 3 b121 NMOSWRAP
VG122 g122 0 2.9121672694464475
RB122 b122 0 10
X122 17 g122 3 b122 NMOSWRAP
VG123 g123 0 2.2879803984592746
RB123 b123 0 10
X123 17 g123 4 b123 NMOSWRAP
VG124 g124 0 1.8477100971163594
RB124 b124 0 10
X124 17 g124 4 b124 NMOSWRAP
VG125 g125 0 2.2127864282558489
RB125 b125 0 10
X125 17 g125 4 b125 NMOSWRAP
VG126 g126 0 1.0383863966186671
RB126 b126 0 10
X126 17 g126 5 b126 NMOSWRAP
VG127 g127 0 1.6031496333490987
RB127 b127 0 10
X127 17 g127 5 b127 NMOSWRAP
VG128 g128 0 2.3203470749853699
RB128 b128 0 10
X128 17 g128 5 b128 NMOSWRAP
VG129 g129 0 1.5801552144208881
RB129 b129 0 10
X129 17 g129 6 b129 NMOSWRAP
VG130 g130 0 2.2360308579976831
RB130 b130 0 10
X130 17 g130 6 b130 NMOSWRAP
VG131 g131 0 1.8575374018915323
RB131 b131 0 10
X131 17 g131 6 b131 NMOSWRAP
VG132 g132 0 1.2709481284449005
RB132 b132 0 10
X132 17 g132 7 b132 NMOSWRAP
VG133 g133 0 1.5965646519120615
RB133 b133 0 10
X133 17 g133 7 b133 NMOSWRAP
VG134 g134 0 2.1399298214025295
RB134 b134 0 10
X134 17 g134 7 b134 NMOSWRAP
VG135 g135 0 2.1817455224963465
RB135 b135 0 10
X135 17 g135 8 b135 NMOSWRAP
VG136 g136 0 2.1486504976991574
RB136 b136 0 10
X136 17 g136 8 b136 NMOSWRAP
VG137 g137 0 2.3064016397142675
RB137 b137 0 10
X137 17 g137 8 b137 NMOSWRAP
VG138 g138 0 2.3042065400033778
RB138 b138 0 10
X138 17 g138 9 b138 NMOSWRAP
VG139 g139 0 1.8628368708679479
RB139 b139 0 10
X139 17 g139 9 b139 NMOSWRAP
VG140 g140 0 2.7930931917021260
RB140 b140 0 10
X140 17 g140 9 b140 NMOSWRAP
VG141 g141 0 1.7351237400957931
RB141 b141 0 10
X141 17 g141 10 b141 NMOSWRAP
VG142 g142 0 1.8717298505312536
RB142 b142 0 10
X142 17 g142 10 b142 NMOSWRAP
VG143 g143 0 2.7838467100313444
RB143 b143 0 10
X143 17 g143 10 b143 NMOSWRAP
VG144 g144 0 2.6123879780921717
RB144 b144 0 10
X144 17 g144 11 b144 NMOSWRAP
VG145 g145 0 2.4077771670807326
RB145 b145 0 10
X145 17 g145 11 b145 NMOSWRAP
VG146 g146 0 1.2004537746246022
RB146 b146 0 10
X146 17 g146 11 b146 NMOSWRAP
VG147 g147 0 2.8389652274893473
RB147 b147 0 10
X147 17 g147 12 b147 NMOSWRAP
VG148 g148 0 2.4284825990982228
RB148 b148 0 10
X148 17 g148 12 b148 NMOSWRAP
VG149 g149 0 2.9976940131357330
RB149 b149 0 10
X149 17 g149 12 b149 NMOSWRAP
VG150 g150 0 1.2988966093159875
RB150 b150 0 10
X150 18 g150 3 b150 NMOSWRAP
VG151 g151 0 2.7362521147364287
RB151 b151 0 10
X151 18 g151 3 b151 NMOSWRAP
VG152 g152 0 1.3249858693527496
RB152 b152 0 10
X152 18 g152 4 b152 NMOSWRAP
VG153 g153 0 2.2311191285676886
RB153 b153 0 10
X153 18 g153 4 b153 NMOSWRAP
VG154 g154 0 1.2476399656988830
RB154 b154 0 10
X154 18 g154 4 b154 NMOSWRAP
VG155 g155 0 2.6960164586444688
RB155 b155 0 10
X155 18 g155 5 b155 NMOSWRAP
VG156 g156 0 2.6146379174500214
RB156 b156 0 10
X156 18 g156 5 b156 NMOSWRAP
VG157 g157 0 2.1382014772291864
RB157 b157 0 10
X157 18 g157 5 b157 NMOSWRAP
VG158 g158 0 1.8143665944519993
RB158 b158 0 10
X158 18 g158 6 b158 NMOSWRAP
VG159 g159 0 1.1383339909102761
RB159 b159 0 10
X159 18 g159 6 b159 NMOSWRAP
VG160 g160 0 2.3948575462891273
RB160 b160 0 10
X160 18 g160 6 b160 NMOSWRAP
VG161 g161 0 1.9070853653561377
RB161 b161 0 10
X161 18 g161 7 b161 NMOSWRAP
VG162 g162 0 2.4441111989406958
RB162 b162 0 10
X162 18 g162 7 b162 NMOSWRAP
VG163 g163 0 2.7327646518572584
RB163 b163 0 10
X163 18 g163 7 b163 NMOSWRAP
VG164 g164 0 2.9510430100057716
RB164 b164 0 10
X164 18 g164 8 b164 NMOSWRAP
VG165 g165 0 2.7116066847852220
RB165 b165 0 10
X165 18 g165 8 b165 NMOSWRAP
VG166 g166 0 1.0234281683700039
RB166 b166 0 10
X166 18 g166 8 b166 NMOSWRAP
VG167 g167 0 1.7199561289567278
RB167 b167 0 10
X167 18 g167 9 b167 NMOSWRAP
VG168 g168 0 2.4599811248481158
RB168 b168 0 10
X168 18 g168 9 b168 NMOSWRAP
VG169 g169 0 1.3432593545228810
RB169 b169 0 10
X169 18 g169 9 b169 NMOSWRAP
VG170 g170 0 2.0420732124082583
RB170 b170 0 10
X170 18 g170 10 b170 NMOSWRAP
VG171 g171 0 1.1086759766785073
RB171 b171 0 10
X171 18 g171 10 b171 NMOSWRAP
VG172 g172 0 1.3999930497928001
RB172 b172 0 10
X172 18 g172 10 b172 NMOSWRAP
VG173 g173 0 1.0370435889212279
RB173 b173 0 10
X173 18 g173 11 b173 NMOSWRAP
VG174 g174 0 2.5873954067148413
RB174 b174 0 10
X174 18 g174 11 b174 NMOSWRAP
VG175 g175 0 1.4478493761207603
RB175 b175 0 10
X175 18 g175 11 b175 NMOSWRAP
VG176 g176 0 1.6907033613938054
RB176 b176 0 10
X176 18 g176 12 b176 NMOSWRAP
VG177 g177 0 2.8561625869311817
RB177 b177 0 10
X177 18 g177 12 b177 NMOSWRAP
VG178 g178 0 2.4088288038470655
RB178 b178 0 10
X178 19 g178 3 b178 NMOSWRAP
VG179 g179 0 1.0636778590626157
RB179 b179 0 10
X179 19 g179 3 b179 NMOSWRAP
VG180 g180 0 1.3293883129958255
RB180 b180 0 10
X180 19 g180 3 b180 NMOSWRAP
VG181 g181 0 2.2429568029995268
RB181 b181 0 10
X181 19 g181 4 b181 NMOSWRAP
VG182 g182 0 2.1544571772083350
RB182 b182 0 10
X182 19 g182 4 b182 NMOSWRAP
VG183 g183 0 1.4757856427490172
RB183 b183 0 10
X183 19 g183 4 b183 NMOSWRAP
VG184 g184 0 2.8684279958495873
RB184 b184 0 10
X184 19 g184 5 b184 NMOSWRAP
VG185 g185 0 2.2279319119317922
RB185 b185 0 10
X185 19 g185 5 b185 NMOSWRAP
VG186 g186 0 2.0712656060499164
RB186 b186 0 10
X186 19 g186 5 b186 NMOSWRAP
VG187 g187 0 2.1798199527091420
RB187 b187 0 10
X187 19 g187 6 b187 NMOSWRAP
VG188 g188 0 2.4602440590335393
RB188 b188 0 10
X188 19 g188 6 b188 NMOSWRAP
VG189 g189 0 1.6238899909592037
RB189 b189 0 10
X189 19 g189 6 b189 NMOSWRAP
VG190 g190 0 1.7964421244321838
RB190 b190 0 10
X190 19 g190 7 b190 NMOSWRAP
VG191 g191 0 1.4196874979502443
RB191 b191 0 10
X191 19 g191 7 b191 NMOSWRAP
VG192 g192 0 1.3723860117606723
RB192 b192 0 10
X192 19 g192 7 b192 NMOSWRAP
VG193 g193 0 2.8887447799678672
RB193 b193 0 10
X193 19 g193 8 b193 NMOSWRAP
VG194 g194 0 2.4791015900985753
RB194 b194 0 10
X194 19 g194 8 b194 NMOSWRAP
VG195 g195 0 1.9809176172351342
RB195 b195 0 10
X195 19 g195 8 b195 NMOSWRAP
VG196 g196 0 1.4548292559466465
RB196 b196 0 10
X196 19 g196 9 b196 NMOSWRAP
VG197 g197 0 1.5087129635407859
RB197 b197 0 10
X197 19 g197 9 b197 NMOSWRAP
VG198 g198 0 1.1160583206477512
RB198 b198 0 10
X198 19 g198 9 b198 NMOSWRAP
VG199 g199 0 1.8688332511162415
RB199 b199 0 10
X199 19 g199 10 b199 NMOSWRAP
VG200 g200 0 1.6235917639882051
RB200 b200 0 10
X200 19 g200 10 b200 NMOSWRAP
VG201 g201 0 2.3926869776309188
RB201 b201 0 10
X201 19 g201 10 b201 NMOSWRAP
VG202 g202 0 1.7555036785849618
RB202 b202 0 10
X202 19 g202 11 b202 NMOSWRAP
VG203 g203 0 1.3592073551192696
RB203 b203 0 10
X203 19 g203 11 b203 NMOSWRAP
VG204 g204 0 1.0493574567826625
RB204 b204 0 10
X204 19 g204 11 b204 NMOSWRAP
VG205 g205 0 1.1344992629264972
RB205 b205 0 10
X205 19 g205 12 b205 NMOSWRAP
VG206 g206 0 2.3587855469971348
RB206 b206 0 10
X206 19 g206 12 b206 NMOSWRAP
VG207 g207 0 1.9073936891120906
RB207 b207 0 10
X207 19 g207 12 b207 NMOSWRAP
VG208 g208 0 2.0731584222174444
RB208 b208 0 10
X208 20 g208 3 b208 NMOSWRAP
VG209 g209 0 2.7933425860806844
RB209 b209 0 10
X209 20 g209 3 b209 NMOSWRAP
VG210 g210 0 2.9806778947934087
RB210 b210 0 10
X210 20 g210 3 b210 NMOSWRAP
VG211 g211 0 1.4337939687969479
RB211 b211 0 10
X211 20 g211 4 b211 NMOSWRAP
VG212 g212 0 2.3261564062002016
RB212 b212 0 10
X212 20 g212 4 b212 NMOSWRAP
VG213 g213 0 1.5266447534743013
RB213 b213 0 10
X213 20 g213 4 b213 NMOSWRAP
VG214 g214 0 1.0413019989314574
RB214 b214 0 10
X214 20 g214 5 b214 NMOSWRAP
VG215 g215 0 2.5167573076722829
RB215 b215 0 10
X215 20 g215 5 b215 NMOSWRAP
VG216 g216 0 1.6400343016449357
RB216 b216 0 10
X216 20 g216 5 b216 NMOSWRAP
VG217 g217 0 1.7669277883437959
RB217 b217 0 10
X217 20 g217 6 b217 NMOSWRAP
VG218 g218 0 2.1766342271072112
RB218 b218 0 10
X218 20 g218 6 b218 NMOSWRAP
VG219 g219 0 2.6620969104723811
RB219 b219 0 10
X219 20 g219 6 b219 NMOSWRAP
VG220 g220 0 2.2579636871822975
RB220 b220 0 10
X220 20 g220 7 b220 NMOSWRAP
VG221 g221 0 2.7453013108947903
RB221 b221 0 10
X221 20 g221 7 b221 NMOSWRAP
VG222 g222 0 1.5470840696312715
RB222 b222 0 10
X222 20 g222 7 b222 NMOSWRAP
VG223 g223 0 2.5960936678251274
RB223 b223 0 10
X223 20 g223 8 b223 NMOSWRAP
VG224 g224 0 1.3712718886119044
RB224 b224 0 10
X224 20 g224 8 b224 NMOSWRAP
VG225 g225 0 2.9055833139438891
RB225 b225 0 10
X225 20 g225 8 b225 NMOSWRAP
VG226 g226 0 2.3749765527756308
RB226 b226 0 10
X226 20 g226 9 b226 NMOSWRAP
VG227 g227 0 1.4310153542271169
RB227 b227 0 10
X227 20 g227 9 b227 NMOSWRAP
VG228 g228 0 2.8947411809778485
RB228 b228 0 10
X228 20 g228 9 b228 NMOSWRAP
VG229 g229 0 2.4617116135403156
RB229 b229 0 10
X229 20 g229 10 b229 NMOSWRAP
VG230 g230 0 1.5078832851900517
RB230 b230 0 10
X230 20 g230 10 b230 NMOSWRAP
VG231 g231 0 1.4266239547349640
RB231 b231 0 10
X231 20 g231 10 b231 NMOSWRAP
VG232 g232 0 2.0364014278613265
RB232 b232 0 10
X232 20 g232 11 b232 NMOSWRAP
VG233 g233 0 1.0513254361090631
RB233 b233 0 10
X233 20 g233 11 b233 NMOSWRAP
VG234 g234 0 1.4149401508822188
RB234 b234 0 10
X234 20 g234 11 b234 NMOSWRAP
VG235 g235 0 1.8493709375030125
RB235 b235 0 10
X235 20 g235 12 b235 NMOSWRAP
VG236 g236 0 1.7483399606684511
RB236 b236 0 10
X236 20 g236 12 b236 NMOSWRAP
VG237 g237 0 1.9271508487296214
RB237 b237 0 10
X237 20 g237 12 b237 NMOSWRAP
VG238 g238 0 1.5552574125894638
RB238 b238 0 10
X238 21 g238 3 b238 NMOSWRAP
VG239 g239 0 2.1735686929163376
RB239 b239 0 10
X239 21 g239 3 b239 NMOSWRAP
VG240 g240 0 2.7277112118464628
RB240 b240 0 10
X240 21 g240 3 b240 NMOSWRAP
VG241 g241 0 1.2350637119240662
RB241 b241 0 10
X241 21 g241 4 b241 NMOSWRAP
VG242 g242 0 2.0347582143082281
RB242 b242 0 10
X242 21 g242 4 b242 NMOSWRAP
VG243 g243 0 1.2641362126903066
RB243 b243 0 10
X243 21 g243 4 b243 NMOSWRAP
VG244 g244 0 2.4337193623851876
RB244 b244 0 10
X244 21 g244 5 b244 NMOSWRAP
VG245 g245 0 1.7921194056145875
RB245 b245 0 10
X245 21 g245 5 b245 NMOSWRAP
VG246 g246 0 2.1308426237170179
RB246 b246 0 10
X246 21 g246 5 b246 NMOSWRAP
VG247 g247 0 1.3665596724281572
RB247 b247 0 10
X247 21 g247 6 b247 NMOSWRAP
VG248 g248 0 1.2896955186867545
RB248 b248 0 10
X248 21 g248 6 b248 NMOSWRAP
VG249 g249 0 1.9761125612979091
RB249 b249 0 10
X249 21 g249 6 b249 NMOSWRAP
VG250 g250 0 1.7112254756999112
RB250 b250 0 10
X250 21 g250 7 b250 NMOSWRAP
VG251 g251 0 2.8808638905056263
RB251 b251 0 10
X251 21 g251 7 b251 NMOSWRAP
VG252 g252 0 2.5306505076139305
RB252 b252 0 10
X252 21 g252 7 b252 NMOSWRAP
VG253 g253 0 2.4973272397010948
RB253 b253 0 10
X253 21 g253 8 b253 NMOSWRAP
VG254 g254 0 2.8074394794918671
RB254 b254 0 10
X254 21 g254 8 b254 NMOSWRAP
VG255 g255 0 1.1668448708840371
RB255 b255 0 10
X255 21 g255 8 b255 NMOSWRAP
VG256 g256 0 2.1043849398448131
RB256 b256 0 10
X256 21 g256 9 b256 NMOSWRAP
VG257 g257 0 2.1689521379115377
RB257 b257 0 10
X257 21 g257 9 b257 NMOSWRAP
VG258 g258 0 2.9238727570944580
RB258 b258 0 10
X258 21 g258 9 b258 NMOSWRAP
VG259 g259 0 1.5842950535850977
RB259 b259 0 10
X259 21 g259 10 b259 NMOSWRAP
VG260 g260 0 1.4816575598308936
RB260 b260 0 10
X260 21 g260 10 b260 NMOSWRAP
VG261 g261 0 1.2005878845309956
RB261 b261 0 10
X261 21 g261 10 b261 NMOSWRAP
VG262 g262 0 1.0328592591829484
RB262 b262 0 10
X262 21 g262 11 b262 NMOSWRAP
VG263 g263 0 2.8590586335843811
RB263 b263 0 10
X263 21 g263 11 b263 NMOSWRAP
VG264 g264 0 2.3398330931818201
RB264 b264 0 10
X264 21 g264 11 b264 NMOSWRAP
VG265 g265 0 2.5703058240462755
RB265 b265 0 10
X265 21 g265 12 b265 NMOSWRAP
VG266 g266 0 1.5634602115078982
RB266 b266 0 10
X266 21 g266 12 b266 NMOSWRAP
VG267 g267 0 2.1728203323726536
RB267 b267 0 10
X267 21 g267 12 b267 NMOSWRAP
VG268 g268 0 1.1279105322419622
RB268 b268 0 10
X268 22 g268 3 b268 NMOSWRAP
VG269 g269 0 1.9712551918692458
RB269 b269 0 10
X269 22 g269 3 b269 NMOSWRAP
VG270 g270 0 2.9549902794888938
RB270 b270 0 10
X270 22 g270 3 b270 NMOSWRAP
VG271 g271 0 2.7530104906331818
RB271 b271 0 10
X271 22 g271 4 b271 NMOSWRAP
VG272 g272 0 1.6763179036736913
RB272 b272 0 10
X272 22 g272 4 b272 NMOSWRAP
VG273 g273 0 2.9231403090829970
RB273 b273 0 10
X273 22 g273 4 b273 NMOSWRAP
VG274 g274 0 1.4634032529424090
RB274 b274 0 10
X274 22 g274 5 b274 NMOSWRAP
VG275 g275 0 2.8986376448313629
RB275 b275 0 10
X275 22 g275 5 b275 NMOSWRAP
VG276 g276 0 2.8827554094129972
RB276 b276 0 10
X276 22 g276 5 b276 NMOSWRAP
VG277 g277 0 2.5984051747047836
RB277 b277 0 10
X277 22 g277 6 b277 NMOSWRAP
VG278 g278 0 2.2608958737335820
RB278 b278 0 10
X278 22 g278 6 b278 NMOSWRAP
VG279 g279 0 2.7485759332498940
RB279 b279 0 10
X279 22 g279 6 b279 NMOSWRAP
VG280 g280 0 1.5860405690155934
RB280 b280 0 10
X280 22 g280 7 b280 NMOSWRAP
VG281 g281 0 2.6978871106258362
RB281 b281 0 10
X281 22 g281 7 b281 NMOSWRAP
VG282 g282 0 2.2357533838350476
RB282 b282 0 10
X282 22 g282 7 b282 NMOSWRAP
VG283 g283 0 1.0264737155177990
RB283 b283 0 10
X283 22 g283 8 b283 NMOSWRAP
VG284 g284 0 1.6944670358644391
RB284 b284 0 10
X284 22 g284 8 b284 NMOSWRAP
VG285 g285 0 1.2962817218963301
RB285 b285 0 10
X285 22 g285 8 b285 NMOSWRAP
VG286 g286 0 2.9636587796365061
RB286 b286 0 10
X286 22 g286 9 b286 NMOSWRAP
VG287 g287 0 1.9567406140799761
RB287 b287 0 10
X287 22 g287 9 b287 NMOSWRAP
VG288 g288 0 1.9947827309973254
RB288 b288 0 10
X288 22 g288 9 b288 NMOSWRAP
VG289 g289 0 2.2789450327974472
RB289 b289 0 10
X289 22 g289 10 b289 NMOSWRAP
VG290 g290 0 1.7371692122592350
RB290 b290 0 10
X290 22 g290 10 b290 NMOSWRAP
VG291 g291 0 1.2738005433711979
RB291 b291 0 10
X291 22 g291 10 b291 NMOSWRAP
VG292 g292 0 2.6442354663884911
RB292 b292 0 10
X292 22 g292 11 b292 NMOSWRAP
VG293 g293 0 1.3796958238055159
RB293 b293 0 10
X293 22 g293 11 b293 NMOSWRAP
VG294 g294 0 2.0226379650929118
RB294 b294 0 10
X294 22 g294 11 b294 NMOSWRAP
VG295 g295 0 1.4486340579494785
RB295 b295 0 10
X295 22 g295 12 b295 NMOSWRAP
VG296 g296 0 1.1956889689880681
RB296 b296 0 10
X296 22 g296 12 b296 NMOSWRAP
VG297 g297 0 2.7243830348433669
RB297 b297 0 10
X297 22 g297 12 b297 NMOSWRAP
VG298 g298 0 2.9458389780462606
RB298 b298 0 10
X298 23 g298 3 b298 NMOSWRAP
VG299 g299 0 2.9216693161260006
RB299 b299 0 10
X299 23 g299 3 b299 NMOSWRAP
VG300 g300 0 2.8131109984423581
RB300 b300 0 10
X300 23 g300 3 b300 NMOSWRAP
VG301 g301 0 2.5480946653972776
RB301 b301 0 10
X301 23 g301 5 b301 NMOSWRAP
VG302 g302 0 1.6662903040572838
RB302 b302 0 10
X302 23 g302 5 b302 NMOSWRAP
VG303 g303 0 1.1622027799759935
RB303 b303 0 10
X303 23 g303 5 b303 NMOSWRAP
VG304 g304 0 1.8144823428276147
RB304 b304 0 10
X304 23 g304 6 b304 NMOSWRAP
VG305 g305 0 1.4644682843418855
RB305 b305 0 10
X305 23 g305 6 b305 NMOSWRAP
VG306 g306 0 1.2649752695159659
RB306 b306 0 10
X306 23 g306 6 b306 NMOSWRAP
VG307 g307 0 1.1068543635736505
RB307 b307 0 10
X307 23 g307 7 b307 NMOSWRAP
VG308 g308 0 2.4511887284211573
RB308 b308 0 10
X308 23 g308 8 b308 NMOSWRAP
VG309 g309 0 1.0228549172500621
RB309 b309 0 10
X309 23 g309 8 b309 NMOSWRAP
VG310 g310 0 2.5411614970055525
RB310 b310 0 10
X310 23 g310 8 b310 NMOSWRAP
VG311 g311 0 1.2938932908007501
RB311 b311 0 10
X311 23 g311 9 b311 NMOSWRAP
VG312 g312 0 1.1590441651735115
RB312 b312 0 10
X312 23 g312 9 b312 NMOSWRAP
VG313 g313 0 1.1792060684772108
RB313 b313 0 10
X313 23 g313 9 b313 NMOSWRAP
VG314 g314 0 2.3440956147078289
RB314 b314 0 10
X314 23 g314 10 b314 NMOSWRAP
VG315 g315 0 1.4907344197056895
RB315 b315 0 10
X315 23 g315 10 b315 NMOSWRAP
VG316 g316 0 1.8410789333601969
RB316 b316 0 10
X316 23 g316 10 b316 NMOSWRAP
VG317 g317 0 2.1147375826478338
RB317 b317 0 10
X317 23 g317 11 b317 NMOSWRAP
VG318 g318 0 2.7211023476575873
RB318 b318 0 10
X318 23 g318 11 b318 NMOSWRAP
VG319 g319 0 2.4540885254226565
RB319 b319 0 10
X319 23 g319 11 b319 NMOSWRAP
VG320 g320 0 1.5406558104774293
RB320 b320 0 10
X320 23 g320 12 b320 NMOSWRAP
VG321 g321 0 1.2629655985822552
RB321 b321 0 10
X321 23 g321 12 b321 NMOSWRAP
VG322 g322 0 1.1107486408423959
RB322 b322 0 10
X322 23 g322 12 b322 NMOSWRAP
VG323 g323 0 1.6031972689618850
RB323 b323 0 10
X323 24 g323 3 b323 NMOSWRAP
VG324 g324 0 1.5242362984793565
RB324 b324 0 10
X324 24 g324 3 b324 NMOSWRAP
VG325 g325 0 1.9122811336009593
RB325 b325 0 10
X325 24 g325 3 b325 NMOSWRAP
VG326 g326 0 2.3665626710953607
RB326 b326 0 10
X326 24 g326 4 b326 NMOSWRAP
VG327 g327 0 2.3912508912777142
RB327 b327 0 10
X327 24 g327 4 b327 NMOSWRAP
VG328 g328 0 1.5670376931643333
RB328 b328 0 10
X328 24 g328 4 b328 NMOSWRAP
VG329 g329 0 1.7598539118002410
RB329 b329 0 10
X329 24 g329 5 b329 NMOSWRAP
VG330 g330 0 1.3623019234738061
RB330 b330 0 10
X330 24 g330 5 b330 NMOSWRAP
VG331 g331 0 2.5770910246130372
RB331 b331 0 10
X331 24 g331 5 b331 NMOSWRAP
VG332 g332 0 1.1136961528664806
RB332 b332 0 10
X332 24 g332 6 b332 NMOSWRAP
VG333 g333 0 2.3939944834499745
RB333 b333 0 10
X333 24 g333 6 b333 NMOSWRAP
VG334 g334 0 2.5573907918822067
RB334 b334 0 10
X334 24 g334 6 b334 NMOSWRAP
VG335 g335 0 2.5548151236975061
RB335 b335 0 10
X335 24 g335 7 b335 NMOSWRAP
VG336 g336 0 1.5188451286907099
RB336 b336 0 10
X336 24 g336 7 b336 NMOSWRAP
VG337 g337 0 1.7476262758651229
RB337 b337 0 10
X337 24 g337 7 b337 NMOSWRAP
VG338 g338 0 2.1751992703927781
RB338 b338 0 10
X338 24 g338 8 b338 NMOSWRAP
VG339 g339 0 1.5456438048489340
RB339 b339 0 10
X339 24 g339 8 b339 NMOSWRAP
VG340 g340 0 1.7417055984357774
RB340 b340 0 10
X340 24 g340 8 b340 NMOSWRAP
VG341 g341 0 1.3941085603712793
RB341 b341 0 10
X341 24 g341 9 b341 NMOSWRAP
VG342 g342 0 1.9197117675120148
RB342 b342 0 10
X342 24 g342 9 b342 NMOSWRAP
VG343 g343 0 1.0892246025082282
RB343 b343 0 10
X343 24 g343 9 b343 NMOSWRAP
VG344 g344 0 2.5995917691412362
RB344 b344 0 10
X344 24 g344 10 b344 NMOSWRAP
VG345 g345 0 1.1539128939732655
RB345 b345 0 10
X345 24 g345 10 b345 NMOSWRAP
VG346 g346 0 2.0376702976630519
RB346 b346 0 10
X346 24 g346 10 b346 NMOSWRAP
VG347 g347 0 1.6136201990903922
RB347 b347 0 10
X347 24 g347 11 b347 NMOSWRAP
VG348 g348 0 2.1550858976627509
RB348 b348 0 10
X348 24 g348 11 b348 NMOSWRAP
VG349 g349 0 2.9188666816668505
RB349 b349 0 10
X349 24 g349 11 b349 NMOSWRAP
VG350 g350 0 2.2911404889120077
RB350 b350 0 10
X350 24 g350 12 b350 NMOSWRAP
VG351 g351 0 1.0707248715109818
RB351 b351 0 10
X351 24 g351 12 b351 NMOSWRAP
VG352 g352 0 1.8608048790161225
RB352 b352 0 10
X352 24 g352 12 b352 NMOSWRAP
VG353 g353 0 2.0200337046365004
RB353 b353 0 10
X353 25 g353 3 b353 NMOSWRAP
VG354 g354 0 2.0723549894069038
RB354 b354 0 10
X354 25 g354 3 b354 NMOSWRAP
VG355 g355 0 2.3627850212076758
RB355 b355 0 10
X355 25 g355 3 b355 NMOSWRAP
VG356 g356 0 1.5551921954635322
RB356 b356 0 10
X356 25 g356 4 b356 NMOSWRAP
VG357 g357 0 1.2577211309326404
RB357 b357 0 10
X357 25 g357 4 b357 NMOSWRAP
VG358 g358 0 1.7853513530941887
RB358 b358 0 10
X358 25 g358 4 b358 NMOSWRAP
VG359 g359 0 2.9128114455918976
RB359 b359 0 10
X359 25 g359 5 b359 NMOSWRAP
VG360 g360 0 1.3742617835016895
RB360 b360 0 10
X360 25 g360 5 b360 NMOSWRAP
VG361 g361 0 2.8079679098564743
RB361 b361 0 10
X361 25 g361 5 b361 NMOSWRAP
VG362 g362 0 2.0876119001546529
RB362 b362 0 10
X362 25 g362 6 b362 NMOSWRAP
VG363 g363 0 1.9138228432915316
RB363 b363 0 10
X363 25 g363 6 b363 NMOSWRAP
VG364 g364 0 2.7640828204597794
RB364 b364 0 10
X364 25 g364 6 b364 NMOSWRAP
VG365 g365 0 1.9172079235371717
RB365 b365 0 10
X365 25 g365 7 b365 NMOSWRAP
VG366 g366 0 2.4483352732230865
RB366 b366 0 10
X366 25 g366 7 b366 NMOSWRAP
VG367 g367 0 1.7980506434062040
RB367 b367 0 10
X367 25 g367 7 b367 NMOSWRAP
VG368 g368 0 2.8080887858019157
RB368 b368 0 10
X368 25 g368 8 b368 NMOSWRAP
VG369 g369 0 2.3800500403824545
RB369 b369 0 10
X369 25 g369 8 b369 NMOSWRAP
VG370 g370 0 2.3992441085010334
RB370 b370 0 10
X370 25 g370 8 b370 NMOSWRAP
VG371 g371 0 1.6554408031142378
RB371 b371 0 10
X371 25 g371 9 b371 NMOSWRAP
VG372 g372 0 2.5135572854737784
RB372 b372 0 10
X372 25 g372 9 b372 NMOSWRAP
VG373 g373 0 2.2721221108942826
RB373 b373 0 10
X373 25 g373 9 b373 NMOSWRAP
VG374 g374 0 1.4800405467594191
RB374 b374 0 10
X374 25 g374 10 b374 NMOSWRAP
VG375 g375 0 1.3210776449705128
RB375 b375 0 10
X375 25 g375 10 b375 NMOSWRAP
VG376 g376 0 2.5927829490346634
RB376 b376 0 10
X376 25 g376 10 b376 NMOSWRAP
VG377 g377 0 2.9183332060704448
RB377 b377 0 10
X377 25 g377 11 b377 NMOSWRAP
VG378 g378 0 1.9162776545200857
RB378 b378 0 10
X378 25 g378 11 b378 NMOSWRAP
VG379 g379 0 2.1819683306473698
RB379 b379 0 10
X379 25 g379 11 b379 NMOSWRAP
VG380 g380 0 2.7154452883871092
RB380 b380 0 10
X380 25 g380 12 b380 NMOSWRAP
VG381 g381 0 1.9144469067077141
RB381 b381 0 10
X381 25 g381 12 b381 NMOSWRAP
VG382 g382 0 2.9037489536654721
RB382 b382 0 10
X382 25 g382 12 b382 NMOSWRAP
VG383 g383 0 2.1515023240897451
RB383 b383 0 10
X383 26 g383 3 b383 NMOSWRAP
VG384 g384 0 2.6415342414026299
RB384 b384 0 10
X384 26 g384 3 b384 NMOSWRAP
VG385 g385 0 2.8176874368254765
RB385 b385 0 10
X385 26 g385 3 b385 NMOSWRAP
VG386 g386 0 2.6310476375371374
RB386 b386 0 10
X386 26 g386 4 b386 NMOSWRAP
VG387 g387 0 1.3188289268979119
RB387 b387 0 10
X387 26 g387 4 b387 NMOSWRAP
VG388 g388 0 2.2577968781234006
RB388 b388 0 10
X388 26 g388 5 b388 NMOSWRAP
VG389 g389 0 1.7968685172393541
RB389 b389 0 10
X389 26 g389 5 b389 NMOSWRAP
VG390 g390 0 1.1254259040466914
RB390 b390 0 10
X390 26 g390 5 b390 NMOSWRAP
VG391 g391 0 1.8480645037796839
RB391 b391 0 10
X391 26 g391 6 b391 NMOSWRAP
VG392 g392 0 1.5173681337788154
RB392 b392 0 10
X392 26 g392 6 b392 NMOSWRAP
VG393 g393 0 2.6980766168570218
RB393 b393 0 10
X393 26 g393 6 b393 NMOSWRAP
VG394 g394 0 1.0666092530933924
RB394 b394 0 10
X394 26 g394 7 b394 NMOSWRAP
VG395 g395 0 2.9179654437269473
RB395 b395 0 10
X395 26 g395 7 b395 NMOSWRAP
VG396 g396 0 1.7107376969438592
RB396 b396 0 10
X396 26 g396 8 b396 NMOSWRAP
VG397 g397 0 1.7134137808050858
RB397 b397 0 10
X397 26 g397 8 b397 NMOSWRAP
VG398 g398 0 1.0326570053674158
RB398 b398 0 10
X398 26 g398 8 b398 NMOSWRAP
VG399 g399 0 1.3704646504723679
RB399 b399 0 10
X399 26 g399 9 b399 NMOSWRAP
VG400 g400 0 1.8025190016072175
RB400 b400 0 10
X400 26 g400 10 b400 NMOSWRAP
VG401 g401 0 2.8585828346054276
RB401 b401 0 10
X401 26 g401 10 b401 NMOSWRAP
VG402 g402 0 1.1992298604425427
RB402 b402 0 10
X402 26 g402 10 b402 NMOSWRAP
VG403 g403 0 2.8906030669581591
RB403 b403 0 10
X403 26 g403 11 b403 NMOSWRAP
VG404 g404 0 2.7389770610932644
RB404 b404 0 10
X404 26 g404 11 b404 NMOSWRAP
VG405 g405 0 1.9083247938151036
RB405 b405 0 10
X405 26 g405 11 b405 NMOSWRAP
VG406 g406 0 1.6534017635365201
RB406 b406 0 10
X406 26 g406 12 b406 NMOSWRAP
VG407 g407 0 1.4654882585581137
RB407 b407 0 10
X407 26 g407 12 b407 NMOSWRAP
VG408 g408 0 2.2289294129537485
RB408 b408 0 10
X408 26 g408 12 b408 NMOSWRAP
VG409 g409 0 1.0661491829510112
RB409 b409 0 10
X409 27 g409 3 b409 NMOSWRAP
VG410 g410 0 1.0312121288936564
RB410 b410 0 10
X410 27 g410 3 b410 NMOSWRAP
VG411 g411 0 1.8575914449964757
RB411 b411 0 10
X411 27 g411 3 b411 NMOSWRAP
VG412 g412 0 1.1361481479494404
RB412 b412 0 10
X412 27 g412 4 b412 NMOSWRAP
VG413 g413 0 1.5038819764921858
RB413 b413 0 10
X413 27 g413 4 b413 NMOSWRAP
VG414 g414 0 1.4423218306921677
RB414 b414 0 10
X414 27 g414 4 b414 NMOSWRAP
VG415 g415 0 1.5063823874457039
RB415 b415 0 10
X415 27 g415 5 b415 NMOSWRAP
VG416 g416 0 1.2621104624305155
RB416 b416 0 10
X416 27 g416 5 b416 NMOSWRAP
VG417 g417 0 1.0240724457953085
RB417 b417 0 10
X417 27 g417 5 b417 NMOSWRAP
VG418 g418 0 1.2309685942774962
RB418 b418 0 10
X418 27 g418 6 b418 NMOSWRAP
VG419 g419 0 2.2369605190254958
RB419 b419 0 10
X419 27 g419 6 b419 NMOSWRAP
VG420 g420 0 2.9485124256361006
RB420 b420 0 10
X420 27 g420 6 b420 NMOSWRAP
VG421 g421 0 2.9806900031217878
RB421 b421 0 10
X421 27 g421 7 b421 NMOSWRAP
VG422 g422 0 1.8181081907461232
RB422 b422 0 10
X422 27 g422 7 b422 NMOSWRAP
VG423 g423 0 1.3259088520932107
RB423 b423 0 10
X423 27 g423 7 b423 NMOSWRAP
VG424 g424 0 2.2775235147330584
RB424 b424 0 10
X424 27 g424 8 b424 NMOSWRAP
VG425 g425 0 1.9806106930974743
RB425 b425 0 10
X425 27 g425 8 b425 NMOSWRAP
VG426 g426 0 2.9788195545688629
RB426 b426 0 10
X426 27 g426 8 b426 NMOSWRAP
VG427 g427 0 1.1306084143035604
RB427 b427 0 10
X427 27 g427 9 b427 NMOSWRAP
VG428 g428 0 2.5664688766276260
RB428 b428 0 10
X428 27 g428 9 b428 NMOSWRAP
VG429 g429 0 1.5767969946629878
RB429 b429 0 10
X429 27 g429 9 b429 NMOSWRAP
VG430 g430 0 1.4828372401531480
RB430 b430 0 10
X430 27 g430 10 b430 NMOSWRAP
VG431 g431 0 2.3250091430653521
RB431 b431 0 10
X431 27 g431 10 b431 NMOSWRAP
VG432 g432 0 1.4921263699819289
RB432 b432 0 10
X432 27 g432 10 b432 NMOSWRAP
VG433 g433 0 2.3317182351183754
RB433 b433 0 10
X433 27 g433 11 b433 NMOSWRAP
VG434 g434 0 2.0346170344045778
RB434 b434 0 10
X434 27 g434 11 b434 NMOSWRAP
VG435 g435 0 1.8481779768716986
RB435 b435 0 10
X435 27 g435 11 b435 NMOSWRAP
VG436 g436 0 2.1093756173228382
RB436 b436 0 10
X436 27 g436 12 b436 NMOSWRAP
VG437 g437 0 1.5741030398392595
RB437 b437 0 10
X437 27 g437 12 b437 NMOSWRAP
VG438 g438 0 2.4131494125459581
RB438 b438 0 10
X438 27 g438 12 b438 NMOSWRAP
VG439 g439 0 1.8297137386671281
RB439 b439 0 10
X439 28 g439 3 b439 NMOSWRAP
VG440 g440 0 1.7210911209717845
RB440 b440 0 10
X440 28 g440 3 b440 NMOSWRAP
VG441 g441 0 2.6573138291114757
RB441 b441 0 10
X441 28 g441 3 b441 NMOSWRAP
VG442 g442 0 2.8499338239063841
RB442 b442 0 10
X442 28 g442 4 b442 NMOSWRAP
VG443 g443 0 1.0920146217745939
RB443 b443 0 10
X443 28 g443 4 b443 NMOSWRAP
VG444 g444 0 1.4652539856595310
RB444 b444 0 10
X444 28 g444 4 b444 NMOSWRAP
VG445 g445 0 1.6970387389851265
RB445 b445 0 10
X445 28 g445 5 b445 NMOSWRAP
VG446 g446 0 2.6299329587404947
RB446 b446 0 10
X446 28 g446 5 b446 NMOSWRAP
VG447 g447 0 2.9709828552865951
RB447 b447 0 10
X447 28 g447 5 b447 NMOSWRAP
VG448 g448 0 2.9379434093407033
RB448 b448 0 10
X448 28 g448 6 b448 NMOSWRAP
VG449 g449 0 2.8098966910998540
RB449 b449 0 10
X449 28 g449 6 b449 NMOSWRAP
VG450 g450 0 1.5931125301280598
RB450 b450 0 10
X450 28 g450 6 b450 NMOSWRAP
VG451 g451 0 2.9840224868289482
RB451 b451 0 10
X451 28 g451 7 b451 NMOSWRAP
VG452 g452 0 1.4988400821129024
RB452 b452 0 10
X452 28 g452 7 b452 NMOSWRAP
VG453 g453 0 1.2118123097644644
RB453 b453 0 10
X453 28 g453 7 b453 NMOSWRAP
VG454 g454 0 2.9019052221107882
RB454 b454 0 10
X454 28 g454 8 b454 NMOSWRAP
VG455 g455 0 1.4668405109361926
RB455 b455 0 10
X455 28 g455 8 b455 NMOSWRAP
VG456 g456 0 2.3795365301555007
RB456 b456 0 10
X456 28 g456 8 b456 NMOSWRAP
VG457 g457 0 1.1167127179611773
RB457 b457 0 10
X457 28 g457 9 b457 NMOSWRAP
VG458 g458 0 2.4614181982549521
RB458 b458 0 10
X458 28 g458 9 b458 NMOSWRAP
VG459 g459 0 2.7634404246676794
RB459 b459 0 10
X459 28 g459 9 b459 NMOSWRAP
VG460 g460 0 1.5448737909319250
RB460 b460 0 10
X460 28 g460 10 b460 NMOSWRAP
VG461 g461 0 1.7581137921548571
RB461 b461 0 10
X461 28 g461 10 b461 NMOSWRAP
VG462 g462 0 1.7485923666418322
RB462 b462 0 10
X462 28 g462 10 b462 NMOSWRAP
VG463 g463 0 2.4975765150802660
RB463 b463 0 10
X463 28 g463 11 b463 NMOSWRAP
VG464 g464 0 1.4756144850780777
RB464 b464 0 10
X464 28 g464 11 b464 NMOSWRAP
VG465 g465 0 1.3437061980952860
RB465 b465 0 10
X465 28 g465 11 b465 NMOSWRAP
VG466 g466 0 1.8985832973754762
RB466 b466 0 10
X466 28 g466 12 b466 NMOSWRAP
VG467 g467 0 1.6089368147546390
RB467 b467 0 10
X467 28 g467 12 b467 NMOSWRAP
VG468 g468 0 2.6783782445173046
RB468 b468 0 10
X468 28 g468 12 b468 NMOSWRAP
VG469 g469 0 1.4754836520312775
RB469 b469 0 10
X469 29 g469 3 b469 NMOSWRAP
VG470 g470 0 2.0047789149785231
RB470 b470 0 10
X470 29 g470 3 b470 NMOSWRAP
VG471 g471 0 2.8851671993958607
RB471 b471 0 10
X471 29 g471 3 b471 NMOSWRAP
VG472 g472 0 2.2679953954893213
RB472 b472 0 10
X472 29 g472 4 b472 NMOSWRAP
VG473 g473 0 2.7345788109249298
RB473 b473 0 10
X473 29 g473 4 b473 NMOSWRAP
VG474 g474 0 2.8804193787095347
RB474 b474 0 10
X474 29 g474 4 b474 NMOSWRAP
VG475 g475 0 2.5015297237727037
RB475 b475 0 10
X475 29 g475 5 b475 NMOSWRAP
VG476 g476 0 2.3991501204495025
RB476 b476 0 10
X476 29 g476 5 b476 NMOSWRAP
VG477 g477 0 2.9359311332084541
RB477 b477 0 10
X477 29 g477 5 b477 NMOSWRAP
VG478 g478 0 2.9888015792953588
RB478 b478 0 10
X478 29 g478 6 b478 NMOSWRAP
VG479 g479 0 1.9036433653395193
RB479 b479 0 10
X479 29 g479 6 b479 NMOSWRAP
VG480 g480 0 1.1417395563684167
RB480 b480 0 10
X480 29 g480 6 b480 NMOSWRAP
VG481 g481 0 1.5855880628810377
RB481 b481 0 10
X481 29 g481 7 b481 NMOSWRAP
VG482 g482 0 1.3047094113754609
RB482 b482 0 10
X482 29 g482 7 b482 NMOSWRAP
VG483 g483 0 1.8349727495920236
RB483 b483 0 10
X483 29 g483 7 b483 NMOSWRAP
VG484 g484 0 1.2625786569465121
RB484 b484 0 10
X484 29 g484 8 b484 NMOSWRAP
VG485 g485 0 2.2082356080417638
RB485 b485 0 10
X485 29 g485 8 b485 NMOSWRAP
VG486 g486 0 1.7656161183157082
RB486 b486 0 10
X486 29 g486 8 b486 NMOSWRAP
VG487 g487 0 2.7907717685764197
RB487 b487 0 10
X487 29 g487 9 b487 NMOSWRAP
VG488 g488 0 2.9355893435970035
RB488 b488 0 10
X488 29 g488 9 b488 NMOSWRAP
VG489 g489 0 2.0937698033388443
RB489 b489 0 10
X489 29 g489 9 b489 NMOSWRAP
VG490 g490 0 1.5496471397351932
RB490 b490 0 10
X490 29 g490 10 b490 NMOSWRAP
VG491 g491 0 2.1844608375236736
RB491 b491 0 10
X491 29 g491 10 b491 NMOSWRAP
VG492 g492 0 2.7935223164488194
RB492 b492 0 10
X492 29 g492 10 b492 NMOSWRAP
VG493 g493 0 1.8134666916714965
RB493 b493 0 10
X493 29 g493 11 b493 NMOSWRAP
VG494 g494 0 2.1041565533839419
RB494 b494 0 10
X494 29 g494 11 b494 NMOSWRAP
VG495 g495 0 1.5433055352122917
RB495 b495 0 10
X495 29 g495 11 b495 NMOSWRAP
VG496 g496 0 1.9108882989000540
RB496 b496 0 10
X496 29 g496 12 b496 NMOSWRAP
VG497 g497 0 1.8034270707591973
RB497 b497 0 10
X497 29 g497 12 b497 NMOSWRAP
VG498 g498 0 1.4968269301659420
RB498 b498 0 10
X498 29 g498 12 b498 NMOSWRAP
VG499 g499 0 2.0117327676506167
RB499 b499 0 10
X499 30 g499 3 b499 NMOSWRAP
VG500 g500 0 1.6207616519596229
RB500 b500 0 10
X500 30 g500 3 b500 NMOSWRAP
VG501 g501 0 1.7460697277614949
RB501 b501 0 10
X501 30 g501 3 b501 NMOSWRAP
VG502 g502 0 2.0499408845085285
RB502 b502 0 10
X502 30 g502 4 b502 NMOSWRAP
VG503 g503 0 2.5011900458579750
RB503 b503 0 10
X503 30 g503 4 b503 NMOSWRAP
VG504 g504 0 1.6670149315825507
RB504 b504 0 10
X504 30 g504 4 b504 NMOSWRAP
VG505 g505 0 2.8483175332415271
RB505 b505 0 10
X505 30 g505 5 b505 NMOSWRAP
VG506 g506 0 2.7246370936718050
RB506 b506 0 10
X506 30 g506 5 b506 NMOSWRAP
VG507 g507 0 1.0973805919510571
RB507 b507 0 10
X507 30 g507 5 b507 NMOSWRAP
VG508 g508 0 1.5072850485136455
RB508 b508 0 10
X508 30 g508 6 b508 NMOSWRAP
VG509 g509 0 1.8922710253184039
RB509 b509 0 10
X509 30 g509 6 b509 NMOSWRAP
VG510 g510 0 1.2092557774849482
RB510 b510 0 10
X510 30 g510 6 b510 NMOSWRAP
VG511 g511 0 1.6969519780669942
RB511 b511 0 10
X511 30 g511 7 b511 NMOSWRAP
VG512 g512 0 2.4801950512353650
RB512 b512 0 10
X512 30 g512 7 b512 NMOSWRAP
VG513 g513 0 2.3610289622856517
RB513 b513 0 10
X513 30 g513 7 b513 NMOSWRAP
VG514 g514 0 2.2447688571320095
RB514 b514 0 10
X514 30 g514 8 b514 NMOSWRAP
VG515 g515 0 2.4210568054446915
RB515 b515 0 10
X515 30 g515 8 b515 NMOSWRAP
VG516 g516 0 1.4098473739194035
RB516 b516 0 10
X516 30 g516 8 b516 NMOSWRAP
VG517 g517 0 1.6833962297294642
RB517 b517 0 10
X517 30 g517 9 b517 NMOSWRAP
VG518 g518 0 2.3524849645549257
RB518 b518 0 10
X518 30 g518 9 b518 NMOSWRAP
VG519 g519 0 2.7584695260626542
RB519 b519 0 10
X519 30 g519 9 b519 NMOSWRAP
VG520 g520 0 2.0873561076561904
RB520 b520 0 10
X520 30 g520 10 b520 NMOSWRAP
VG521 g521 0 1.5653993018910732
RB521 b521 0 10
X521 30 g521 10 b521 NMOSWRAP
VG522 g522 0 1.0604705160119652
RB522 b522 0 10
X522 30 g522 10 b522 NMOSWRAP
VG523 g523 0 2.4206736579484267
RB523 b523 0 10
X523 30 g523 11 b523 NMOSWRAP
VG524 g524 0 1.0157682070168808
RB524 b524 0 10
X524 30 g524 11 b524 NMOSWRAP
VG525 g525 0 1.7453581396419910
RB525 b525 0 10
X525 30 g525 11 b525 NMOSWRAP
VG526 g526 0 2.0610744291255636
RB526 b526 0 10
X526 30 g526 12 b526 NMOSWRAP
VG527 g527 0 2.8442229235343861
RB527 b527 0 10
X527 30 g527 12 b527 NMOSWRAP
VG528 g528 0 1.1789890900658002
RB528 b528 0 10
X528 30 g528 12 b528 NMOSWRAP
VG529 g529 0 1.8118846439365675
RB529 b529 0 10
X529 31 g529 3 b529 NMOSWRAP
VG530 g530 0 1.0486263994203155
RB530 b530 0 10
X530 31 g530 3 b530 NMOSWRAP
VG531 g531 0 1.6852219686831806
RB531 b531 0 10
X531 31 g531 3 b531 NMOSWRAP
VG532 g532 0 2.2444621176795900
RB532 b532 0 10
X532 31 g532 4 b532 NMOSWRAP
VG533 g533 0 1.5581358964571967
RB533 b533 0 10
X533 31 g533 4 b533 NMOSWRAP
VG534 g534 0 1.4194998993112702
RB534 b534 0 10
X534 31 g534 5 b534 NMOSWRAP
VG535 g535 0 1.2314064666541873
RB535 b535 0 10
X535 31 g535 5 b535 NMOSWRAP
VG536 g536 0 2.1542804880406834
RB536 b536 0 10
X536 31 g536 5 b536 NMOSWRAP
VG537 g537 0 2.3905400118093718
RB537 b537 0 10
X537 31 g537 6 b537 NMOSWRAP
VG538 g538 0 2.3439142811916449
RB538 b538 0 10
X538 31 g538 7 b538 NMOSWRAP
VG539 g539 0 2.8977220414410150
RB539 b539 0 10
X539 31 g539 7 b539 NMOSWRAP
VG540 g540 0 1.0054064277870054
RB540 b540 0 10
X540 31 g540 7 b540 NMOSWRAP
VG541 g541 0 2.2943933077880718
RB541 b541 0 10
X541 31 g541 8 b541 NMOSWRAP
VG542 g542 0 2.2007844741952791
RB542 b542 0 10
X542 31 g542 8 b542 NMOSWRAP
VG543 g543 0 2.1774792199405764
RB543 b543 0 10
X543 31 g543 8 b543 NMOSWRAP
VG544 g544 0 2.9255406396804848
RB544 b544 0 10
X544 31 g544 9 b544 NMOSWRAP
VG545 g545 0 1.0337433467400794
RB545 b545 0 10
X545 31 g545 9 b545 NMOSWRAP
VG546 g546 0 2.3929648614029002
RB546 b546 0 10
X546 31 g546 9 b546 NMOSWRAP
VG547 g547 0 2.6273572994037266
RB547 b547 0 10
X547 31 g547 10 b547 NMOSWRAP
VG548 g548 0 2.0196143932431685
RB548 b548 0 10
X548 31 g548 10 b548 NMOSWRAP
VG549 g549 0 1.6679297391936183
RB549 b549 0 10
X549 31 g549 10 b549 NMOSWRAP
VG550 g550 0 2.5816803264548098
RB550 b550 0 10
X550 31 g550 11 b550 NMOSWRAP
VG551 g551 0 1.1944858512648493
RB551 b551 0 10
X551 31 g551 11 b551 NMOSWRAP
VG552 g552 0 1.8840712754598505
RB552 b552 0 10
X552 31 g552 11 b552 NMOSWRAP
VG553 g553 0 2.0399047491416766
RB553 b553 0 10
X553 31 g553 12 b553 NMOSWRAP
VG554 g554 0 2.3879128218690950
RB554 b554 0 10
X554 31 g554 12 b554 NMOSWRAP
VG555 g555 0 1.1817714640648189
RB555 b555 0 10
X555 31 g555 12 b555 NMOSWRAP
VG556 g556 0 1.4555190030757219
RB556 b556 0 10
X556 32 g556 3 b556 NMOSWRAP
VG557 g557 0 1.8206031253802513
RB557 b557 0 10
X557 32 g557 3 b557 NMOSWRAP
VG558 g558 0 2.2465893460402615
RB558 b558 0 10
X558 32 g558 3 b558 NMOSWRAP
VG559 g559 0 2.7739215624348352
RB559 b559 0 10
X559 32 g559 4 b559 NMOSWRAP
VG560 g560 0 2.2376523364827530
RB560 b560 0 10
X560 32 g560 4 b560 NMOSWRAP
VG561 g561 0 1.2669229418698689
RB561 b561 0 10
X561 32 g561 4 b561 NMOSWRAP
VG562 g562 0 2.9611602655745646
RB562 b562 0 10
X562 32 g562 5 b562 NMOSWRAP
VG563 g563 0 2.7435714695109858
RB563 b563 0 10
X563 32 g563 5 b563 NMOSWRAP
VG564 g564 0 2.0054415222906483
RB564 b564 0 10
X564 32 g564 6 b564 NMOSWRAP
VG565 g565 0 2.8446959635932663
RB565 b565 0 10
X565 32 g565 6 b565 NMOSWRAP
VG566 g566 0 2.0827615875142715
RB566 b566 0 10
X566 32 g566 7 b566 NMOSWRAP
VG567 g567 0 2.8466121357783263
RB567 b567 0 10
X567 32 g567 7 b567 NMOSWRAP
VG568 g568 0 2.6597947372066866
RB568 b568 0 10
X568 32 g568 7 b568 NMOSWRAP
VG569 g569 0 2.9365728205885944
RB569 b569 0 10
X569 32 g569 8 b569 NMOSWRAP
VG570 g570 0 2.8395656215563170
RB570 b570 0 10
X570 32 g570 8 b570 NMOSWRAP
VG571 g571 0 1.0720676348571390
RB571 b571 0 10
X571 32 g571 8 b571 NMOSWRAP
VG572 g572 0 1.3495440083218799
RB572 b572 0 10
X572 32 g572 9 b572 NMOSWRAP
VG573 g573 0 1.7782693542023715
RB573 b573 0 10
X573 32 g573 9 b573 NMOSWRAP
VG574 g574 0 2.9042853945908416
RB574 b574 0 10
X574 32 g574 9 b574 NMOSWRAP
VG575 g575 0 1.6000578389518592
RB575 b575 0 10
X575 32 g575 10 b575 NMOSWRAP
VG576 g576 0 1.3209352877752021
RB576 b576 0 10
X576 32 g576 10 b576 NMOSWRAP
VG577 g577 0 2.7726093321731198
RB577 b577 0 10
X577 32 g577 10 b577 NMOSWRAP
VG578 g578 0 1.8927888309664058
RB578 b578 0 10
X578 32 g578 11 b578 NMOSWRAP
VG579 g579 0 2.8157511887086519
RB579 b579 0 10
X579 32 g579 11 b579 NMOSWRAP
VG580 g580 0 1.3204609326402865
RB580 b580 0 10
X580 32 g580 11 b580 NMOSWRAP
VG581 g581 0 2.3222350230161988
RB581 b581 0 10
X581 32 g581 12 b581 NMOSWRAP
VG582 g582 0 1.8805275056589836
RB582 b582 0 10
X582 32 g582 12 b582 NMOSWRAP
VG583 g583 0 1.1529735380605708
RB583 b583 0 10
X583 32 g583 12 b583 NMOSWRAP
VG584 g584 0 2.3929262893050014
RB584 b584 0 10
X584 33 g584 3 b584 NMOSWRAP
VG585 g585 0 1.4947975110783074
RB585 b585 0 10
X585 33 g585 3 b585 NMOSWRAP
VG586 g586 0 1.0792310451590355
RB586 b586 0 10
X586 33 g586 3 b586 NMOSWRAP
VG587 g587 0 1.1198885964991465
RB587 b587 0 10
X587 33 g587 4 b587 NMOSWRAP
VG588 g588 0 1.1221570741335747
RB588 b588 0 10
X588 33 g588 4 b588 NMOSWRAP
VG589 g589 0 2.8154659149700789
RB589 b589 0 10
X589 33 g589 4 b589 NMOSWRAP
VG590 g590 0 2.4797678356582020
RB590 b590 0 10
X590 33 g590 5 b590 NMOSWRAP
VG591 g591 0 2.7961247144274699
RB591 b591 0 10
X591 33 g591 5 b591 NMOSWRAP
VG592 g592 0 2.3451646225930425
RB592 b592 0 10
X592 33 g592 5 b592 NMOSWRAP
VG593 g593 0 2.0578798580617663
RB593 b593 0 10
X593 33 g593 6 b593 NMOSWRAP
VG594 g594 0 1.6088927286947565
RB594 b594 0 10
X594 33 g594 6 b594 NMOSWRAP
VG595 g595 0 2.9959245026573469
RB595 b595 0 10
X595 33 g595 6 b595 NMOSWRAP
VG596 g596 0 1.7243781178787787
RB596 b596 0 10
X596 33 g596 7 b596 NMOSWRAP
VG597 g597 0 1.9412978984278191
RB597 b597 0 10
X597 33 g597 7 b597 NMOSWRAP
VG598 g598 0 1.7564903498469235
RB598 b598 0 10
X598 33 g598 7 b598 NMOSWRAP
VG599 g599 0 2.9590538586709174
RB599 b599 0 10
X599 33 g599 8 b599 NMOSWRAP
VG600 g600 0 1.3493167707900116
RB600 b600 0 10
X600 33 g600 8 b600 NMOSWRAP
VG601 g601 0 1.6559760018161593
RB601 b601 0 10
X601 33 g601 8 b601 NMOSWRAP
VG602 g602 0 2.3606973320300031
RB602 b602 0 10
X602 33 g602 9 b602 NMOSWRAP
VG603 g603 0 1.1264152366772613
RB603 b603 0 10
X603 33 g603 9 b603 NMOSWRAP
VG604 g604 0 2.2144987480230820
RB604 b604 0 10
X604 33 g604 9 b604 NMOSWRAP
VG605 g605 0 1.9552930057528322
RB605 b605 0 10
X605 33 g605 10 b605 NMOSWRAP
VG606 g606 0 1.5679999535242022
RB606 b606 0 10
X606 33 g606 10 b606 NMOSWRAP
VG607 g607 0 1.4768265618481160
RB607 b607 0 10
X607 33 g607 10 b607 NMOSWRAP
VG608 g608 0 2.0290254865975133
RB608 b608 0 10
X608 33 g608 11 b608 NMOSWRAP
VG609 g609 0 1.7358551610740827
RB609 b609 0 10
X609 33 g609 11 b609 NMOSWRAP
VG610 g610 0 1.9130397825253107
RB610 b610 0 10
X610 33 g610 11 b610 NMOSWRAP
VG611 g611 0 1.6749547635284798
RB611 b611 0 10
X611 33 g611 12 b611 NMOSWRAP
VG612 g612 0 2.9409873871919552
RB612 b612 0 10
X612 33 g612 12 b612 NMOSWRAP
VG613 g613 0 1.2668788634912080
RB613 b613 0 10
X613 33 g613 12 b613 NMOSWRAP
VG614 g614 0 1.1936079063567484
RB614 b614 0 10
X614 34 g614 3 b614 NMOSWRAP
VG615 g615 0 1.6867834575818321
RB615 b615 0 10
X615 34 g615 3 b615 NMOSWRAP
VG616 g616 0 2.1820538017409827
RB616 b616 0 10
X616 34 g616 3 b616 NMOSWRAP
VG617 g617 0 2.3183529437000567
RB617 b617 0 10
X617 34 g617 4 b617 NMOSWRAP
VG618 g618 0 1.7945134943360841
RB618 b618 0 10
X618 34 g618 4 b618 NMOSWRAP
VG619 g619 0 2.9985559878443420
RB619 b619 0 10
X619 34 g619 4 b619 NMOSWRAP
VG620 g620 0 1.7037859923860852
RB620 b620 0 10
X620 34 g620 5 b620 NMOSWRAP
VG621 g621 0 2.4428133359199049
RB621 b621 0 10
X621 34 g621 5 b621 NMOSWRAP
VG622 g622 0 2.2751653890615859
RB622 b622 0 10
X622 34 g622 5 b622 NMOSWRAP
VG623 g623 0 2.6261077264949213
RB623 b623 0 10
X623 34 g623 6 b623 NMOSWRAP
VG624 g624 0 2.9524513269076400
RB624 b624 0 10
X624 34 g624 6 b624 NMOSWRAP
VG625 g625 0 2.7795873128910804
RB625 b625 0 10
X625 34 g625 6 b625 NMOSWRAP
VG626 g626 0 2.5291239487154171
RB626 b626 0 10
X626 34 g626 7 b626 NMOSWRAP
VG627 g627 0 2.3964969556365814
RB627 b627 0 10
X627 34 g627 7 b627 NMOSWRAP
VG628 g628 0 1.6709963393517993
RB628 b628 0 10
X628 34 g628 7 b628 NMOSWRAP
VG629 g629 0 1.2953711564134147
RB629 b629 0 10
X629 34 g629 8 b629 NMOSWRAP
VG630 g630 0 1.1252720061196195
RB630 b630 0 10
X630 34 g630 8 b630 NMOSWRAP
VG631 g631 0 1.4838034084029696
RB631 b631 0 10
X631 34 g631 9 b631 NMOSWRAP
VG632 g632 0 1.8645629623625972
RB632 b632 0 10
X632 34 g632 9 b632 NMOSWRAP
VG633 g633 0 2.0439925472599647
RB633 b633 0 10
X633 34 g633 10 b633 NMOSWRAP
VG634 g634 0 2.5461671081097430
RB634 b634 0 10
X634 34 g634 10 b634 NMOSWRAP
VG635 g635 0 2.9174818461131862
RB635 b635 0 10
X635 34 g635 10 b635 NMOSWRAP
VG636 g636 0 1.2346409607696220
RB636 b636 0 10
X636 34 g636 11 b636 NMOSWRAP
VG637 g637 0 1.2140082803875831
RB637 b637 0 10
X637 34 g637 11 b637 NMOSWRAP
VG638 g638 0 2.1793894460271015
RB638 b638 0 10
X638 34 g638 11 b638 NMOSWRAP
VG639 g639 0 2.4907961478945859
RB639 b639 0 10
X639 34 g639 12 b639 NMOSWRAP
VG640 g640 0 2.6963007606939700
RB640 b640 0 10
X640 34 g640 12 b640 NMOSWRAP
VG641 g641 0 2.8716641604335771
RB641 b641 0 10
X641 34 g641 12 b641 NMOSWRAP
VG642 g642 0 2.9668524845212838
RB642 b642 0 10
X642 35 g642 3 b642 NMOSWRAP
VG643 g643 0 1.7996033844490518
RB643 b643 0 10
X643 35 g643 3 b643 NMOSWRAP
VG644 g644 0 1.7606703670551462
RB644 b644 0 10
X644 35 g644 3 b644 NMOSWRAP
VG645 g645 0 1.2956173533945448
RB645 b645 0 10
X645 35 g645 4 b645 NMOSWRAP
VG646 g646 0 2.3698688773671188
RB646 b646 0 10
X646 35 g646 4 b646 NMOSWRAP
VG647 g647 0 2.3135239168816741
RB647 b647 0 10
X647 35 g647 4 b647 NMOSWRAP
VG648 g648 0 2.7241251917024147
RB648 b648 0 10
X648 35 g648 5 b648 NMOSWRAP
VG649 g649 0 1.1945159895752813
RB649 b649 0 10
X649 35 g649 5 b649 NMOSWRAP
VG650 g650 0 1.9955538156506836
RB650 b650 0 10
X650 35 g650 5 b650 NMOSWRAP
VG651 g651 0 2.1621638593441261
RB651 b651 0 10
X651 35 g651 6 b651 NMOSWRAP
VG652 g652 0 1.4831140800798368
RB652 b652 0 10
X652 35 g652 6 b652 NMOSWRAP
VG653 g653 0 1.3380508122583226
RB653 b653 0 10
X653 35 g653 6 b653 NMOSWRAP
VG654 g654 0 2.7191616728392427
RB654 b654 0 10
X654 35 g654 7 b654 NMOSWRAP
VG655 g655 0 1.1170698444711176
RB655 b655 0 10
X655 35 g655 7 b655 NMOSWRAP
VG656 g656 0 1.9412418078361457
RB656 b656 0 10
X656 35 g656 7 b656 NMOSWRAP
VG657 g657 0 1.2316680026017706
RB657 b657 0 10
X657 35 g657 8 b657 NMOSWRAP
VG658 g658 0 1.9141175226627347
RB658 b658 0 10
X658 35 g658 8 b658 NMOSWRAP
VG659 g659 0 2.9599246526846184
RB659 b659 0 10
X659 35 g659 8 b659 NMOSWRAP
VG660 g660 0 1.8474127069109456
RB660 b660 0 10
X660 35 g660 9 b660 NMOSWRAP
VG661 g661 0 2.7142498350091344
RB661 b661 0 10
X661 35 g661 9 b661 NMOSWRAP
VG662 g662 0 1.2346311283663878
RB662 b662 0 10
X662 35 g662 9 b662 NMOSWRAP
VG663 g663 0 1.5425041535237283
RB663 b663 0 10
X663 35 g663 10 b663 NMOSWRAP
VG664 g664 0 1.8075854813346690
RB664 b664 0 10
X664 35 g664 10 b664 NMOSWRAP
VG665 g665 0 1.7996242800186615
RB665 b665 0 10
X665 35 g665 10 b665 NMOSWRAP
VG666 g666 0 2.3427669573403063
RB666 b666 0 10
X666 35 g666 11 b666 NMOSWRAP
VG667 g667 0 1.6894362547510153
RB667 b667 0 10
X667 35 g667 11 b667 NMOSWRAP
VG668 g668 0 2.4275337368200329
RB668 b668 0 10
X668 35 g668 11 b668 NMOSWRAP
VG669 g669 0 2.2783737984507848
RB669 b669 0 10
X669 35 g669 12 b669 NMOSWRAP
VG670 g670 0 1.7983222905095462
RB670 b670 0 10
X670 35 g670 12 b670 NMOSWRAP
VG671 g671 0 1.8635202553086385
RB671 b671 0 10
X671 35 g671 12 b671 NMOSWRAP
VG672 g672 0 2.2290553996206413
RB672 b672 0 10
X672 36 g672 3 b672 NMOSWRAP
VG673 g673 0 1.1400843802892893
RB673 b673 0 10
X673 36 g673 3 b673 NMOSWRAP
VG674 g674 0 2.6448134767113807
RB674 b674 0 10
X674 36 g674 3 b674 NMOSWRAP
VG675 g675 0 2.3068423222272738
RB675 b675 0 10
X675 36 g675 4 b675 NMOSWRAP
VG676 g676 0 2.4526849288356702
RB676 b676 0 10
X676 36 g676 4 b676 NMOSWRAP
VG677 g677 0 2.0738460021647809
RB677 b677 0 10
X677 36 g677 4 b677 NMOSWRAP
VG678 g678 0 1.2209542219834895
RB678 b678 0 10
X678 36 g678 5 b678 NMOSWRAP
VG679 g679 0 1.8100712265938999
RB679 b679 0 10
X679 36 g679 5 b679 NMOSWRAP
VG680 g680 0 1.8107471656971121
RB680 b680 0 10
X680 36 g680 5 b680 NMOSWRAP
VG681 g681 0 1.6420859800864338
RB681 b681 0 10
X681 36 g681 6 b681 NMOSWRAP
VG682 g682 0 1.0599006498094987
RB682 b682 0 10
X682 36 g682 6 b682 NMOSWRAP
VG683 g683 0 2.4745084851929544
RB683 b683 0 10
X683 36 g683 6 b683 NMOSWRAP
VG684 g684 0 1.2195689161250014
RB684 b684 0 10
X684 36 g684 7 b684 NMOSWRAP
VG685 g685 0 2.2126162660901700
RB685 b685 0 10
X685 36 g685 7 b685 NMOSWRAP
VG686 g686 0 2.4064349929344315
RB686 b686 0 10
X686 36 g686 7 b686 NMOSWRAP
VG687 g687 0 2.2695726458673895
RB687 b687 0 10
X687 36 g687 8 b687 NMOSWRAP
VG688 g688 0 2.9182845039559497
RB688 b688 0 10
X688 36 g688 8 b688 NMOSWRAP
VG689 g689 0 1.2065963101702772
RB689 b689 0 10
X689 36 g689 8 b689 NMOSWRAP
VG690 g690 0 2.7343343182103981
RB690 b690 0 10
X690 36 g690 9 b690 NMOSWRAP
VG691 g691 0 1.0583804696978265
RB691 b691 0 10
X691 36 g691 9 b691 NMOSWRAP
VG692 g692 0 2.0698337098541679
RB692 b692 0 10
X692 36 g692 9 b692 NMOSWRAP
VG693 g693 0 1.8084872358785176
RB693 b693 0 10
X693 36 g693 10 b693 NMOSWRAP
VG694 g694 0 2.0483677207875166
RB694 b694 0 10
X694 36 g694 10 b694 NMOSWRAP
VG695 g695 0 1.7301997541200196
RB695 b695 0 10
X695 36 g695 10 b695 NMOSWRAP
VG696 g696 0 1.3811338298801361
RB696 b696 0 10
X696 36 g696 11 b696 NMOSWRAP
VG697 g697 0 1.0382457948973796
RB697 b697 0 10
X697 36 g697 11 b697 NMOSWRAP
VG698 g698 0 2.0362996275823484
RB698 b698 0 10
X698 36 g698 11 b698 NMOSWRAP
VG699 g699 0 2.6855537253696848
RB699 b699 0 10
X699 36 g699 12 b699 NMOSWRAP
VG700 g700 0 1.7464319114895883
RB700 b700 0 10
X700 36 g700 12 b700 NMOSWRAP
VG701 g701 0 1.4457276360299605
RB701 b701 0 10
X701 36 g701 12 b701 NMOSWRAP
VG702 g702 0 1.1610640069436882
RB702 b702 0 10
X702 37 g702 3 b702 NMOSWRAP
VG703 g703 0 1.1706218462374067
RB703 b703 0 10
X703 37 g703 3 b703 NMOSWRAP
VG704 g704 0 1.4427928925855444
RB704 b704 0 10
X704 37 g704 3 b704 NMOSWRAP
VG705 g705 0 1.2000281218431104
RB705 b705 0 10
X705 37 g705 4 b705 NMOSWRAP
VG706 g706 0 1.5300793967289641
RB706 b706 0 10
X706 37 g706 4 b706 NMOSWRAP
VG707 g707 0 1.1322989242339094
RB707 b707 0 10
X707 37 g707 4 b707 NMOSWRAP
VG708 g708 0 1.1312097344198513
RB708 b708 0 10
X708 37 g708 5 b708 NMOSWRAP
VG709 g709 0 2.7125523592455636
RB709 b709 0 10
X709 37 g709 5 b709 NMOSWRAP
VG710 g710 0 1.3242405214176665
RB710 b710 0 10
X710 37 g710 5 b710 NMOSWRAP
VG711 g711 0 2.1193648116468959
RB711 b711 0 10
X711 37 g711 6 b711 NMOSWRAP
VG712 g712 0 2.5469110888980611
RB712 b712 0 10
X712 37 g712 6 b712 NMOSWRAP
VG713 g713 0 1.9128191306781333
RB713 b713 0 10
X713 37 g713 6 b713 NMOSWRAP
VG714 g714 0 1.3067377557186914
RB714 b714 0 10
X714 37 g714 7 b714 NMOSWRAP
VG715 g715 0 1.3991922842402287
RB715 b715 0 10
X715 37 g715 7 b715 NMOSWRAP
VG716 g716 0 1.8659684125623615
RB716 b716 0 10
X716 37 g716 7 b716 NMOSWRAP
VG717 g717 0 2.0564681783570715
RB717 b717 0 10
X717 37 g717 8 b717 NMOSWRAP
VG718 g718 0 1.6988805840970698
RB718 b718 0 10
X718 37 g718 8 b718 NMOSWRAP
VG719 g719 0 2.5629592004693227
RB719 b719 0 10
X719 37 g719 8 b719 NMOSWRAP
VG720 g720 0 2.5020432977127971
RB720 b720 0 10
X720 37 g720 9 b720 NMOSWRAP
VG721 g721 0 2.8544236147462358
RB721 b721 0 10
X721 37 g721 9 b721 NMOSWRAP
VG722 g722 0 1.0579050980539211
RB722 b722 0 10
X722 37 g722 9 b722 NMOSWRAP
VG723 g723 0 2.7913825824204066
RB723 b723 0 10
X723 37 g723 10 b723 NMOSWRAP
VG724 g724 0 1.7851375769243021
RB724 b724 0 10
X724 37 g724 10 b724 NMOSWRAP
VG725 g725 0 2.7567449907599881
RB725 b725 0 10
X725 37 g725 10 b725 NMOSWRAP
VG726 g726 0 2.3815695523130591
RB726 b726 0 10
X726 37 g726 11 b726 NMOSWRAP
VG727 g727 0 2.9746975141479366
RB727 b727 0 10
X727 37 g727 11 b727 NMOSWRAP
VG728 g728 0 2.5185649034333362
RB728 b728 0 10
X728 37 g728 11 b728 NMOSWRAP
VG729 g729 0 1.7290892519935732
RB729 b729 0 10
X729 37 g729 12 b729 NMOSWRAP
VG730 g730 0 2.0021263456695042
RB730 b730 0 10
X730 37 g730 12 b730 NMOSWRAP
VG731 g731 0 1.7527783103887025
RB731 b731 0 10
X731 37 g731 12 b731 NMOSWRAP
VG732 g732 0 1.7298236720424762
RB732 b732 0 10
X732 38 g732 3 b732 NMOSWRAP
VG733 g733 0 1.5218089987621195
RB733 b733 0 10
X733 38 g733 3 b733 NMOSWRAP
VG734 g734 0 1.9919405907469392
RB734 b734 0 10
X734 38 g734 3 b734 NMOSWRAP
VG735 g735 0 2.3634798901387226
RB735 b735 0 10
X735 38 g735 4 b735 NMOSWRAP
VG736 g736 0 1.5546805426104870
RB736 b736 0 10
X736 38 g736 4 b736 NMOSWRAP
VG737 g737 0 2.0487596221544400
RB737 b737 0 10
X737 38 g737 4 b737 NMOSWRAP
VG738 g738 0 1.2347605883411144
RB738 b738 0 10
X738 38 g738 5 b738 NMOSWRAP
VG739 g739 0 1.3196905737083826
RB739 b739 0 10
X739 38 g739 5 b739 NMOSWRAP
VG740 g740 0 1.0936127094243775
RB740 b740 0 10
X740 38 g740 5 b740 NMOSWRAP
VG741 g741 0 2.9414628855412657
RB741 b741 0 10
X741 38 g741 6 b741 NMOSWRAP
VG742 g742 0 1.0077207030205222
RB742 b742 0 10
X742 38 g742 6 b742 NMOSWRAP
VG743 g743 0 1.3571599361153126
RB743 b743 0 10
X743 38 g743 6 b743 NMOSWRAP
VG744 g744 0 2.2257335062339845
RB744 b744 0 10
X744 38 g744 7 b744 NMOSWRAP
VG745 g745 0 1.1627391977066106
RB745 b745 0 10
X745 38 g745 7 b745 NMOSWRAP
VG746 g746 0 2.7637930061936649
RB746 b746 0 10
X746 38 g746 7 b746 NMOSWRAP
VG747 g747 0 2.4392403156845761
RB747 b747 0 10
X747 38 g747 8 b747 NMOSWRAP
VG748 g748 0 2.9327799428757868
RB748 b748 0 10
X748 38 g748 8 b748 NMOSWRAP
VG749 g749 0 2.0152710944815295
RB749 b749 0 10
X749 38 g749 8 b749 NMOSWRAP
VG750 g750 0 1.6008073663169744
RB750 b750 0 10
X750 38 g750 9 b750 NMOSWRAP
VG751 g751 0 2.0990011455905426
RB751 b751 0 10
X751 38 g751 9 b751 NMOSWRAP
VG752 g752 0 2.8616374345959463
RB752 b752 0 10
X752 38 g752 9 b752 NMOSWRAP
VG753 g753 0 2.0415228744837211
RB753 b753 0 10
X753 38 g753 10 b753 NMOSWRAP
VG754 g754 0 1.5344140637246373
RB754 b754 0 10
X754 38 g754 10 b754 NMOSWRAP
VG755 g755 0 2.7547975783482395
RB755 b755 0 10
X755 38 g755 10 b755 NMOSWRAP
VG756 g756 0 1.7438374970249226
RB756 b756 0 10
X756 38 g756 11 b756 NMOSWRAP
VG757 g757 0 1.0027666999979983
RB757 b757 0 10
X757 38 g757 11 b757 NMOSWRAP
VG758 g758 0 1.4953700449846319
RB758 b758 0 10
X758 38 g758 11 b758 NMOSWRAP
VG759 g759 0 1.6364670183541248
RB759 b759 0 10
X759 38 g759 12 b759 NMOSWRAP
VG760 g760 0 2.7175549364638041
RB760 b760 0 10
X760 38 g760 12 b760 NMOSWRAP
VG761 g761 0 1.9170063341328900
RB761 b761 0 10
X761 38 g761 12 b761 NMOSWRAP
VG762 g762 0 1.8891745756226015
RB762 b762 0 10
X762 39 g762 3 b762 NMOSWRAP
VG763 g763 0 1.6722045327997748
RB763 b763 0 10
X763 39 g763 3 b763 NMOSWRAP
VG764 g764 0 2.7613562460941594
RB764 b764 0 10
X764 39 g764 3 b764 NMOSWRAP
VG765 g765 0 2.8900535538807830
RB765 b765 0 10
X765 39 g765 4 b765 NMOSWRAP
VG766 g766 0 2.9837806583092590
RB766 b766 0 10
X766 39 g766 4 b766 NMOSWRAP
VG767 g767 0 1.7534825339219735
RB767 b767 0 10
X767 39 g767 4 b767 NMOSWRAP
VG768 g768 0 2.9322948912543430
RB768 b768 0 10
X768 39 g768 5 b768 NMOSWRAP
VG769 g769 0 2.5837591392618027
RB769 b769 0 10
X769 39 g769 5 b769 NMOSWRAP
VG770 g770 0 2.3513782952885336
RB770 b770 0 10
X770 39 g770 6 b770 NMOSWRAP
VG771 g771 0 1.4897789588401988
RB771 b771 0 10
X771 39 g771 7 b771 NMOSWRAP
VG772 g772 0 1.4329145218884196
RB772 b772 0 10
X772 39 g772 7 b772 NMOSWRAP
VG773 g773 0 1.3320956490424913
RB773 b773 0 10
X773 39 g773 7 b773 NMOSWRAP
VG774 g774 0 2.8455132204507310
RB774 b774 0 10
X774 39 g774 8 b774 NMOSWRAP
VG775 g775 0 1.5881533247663322
RB775 b775 0 10
X775 39 g775 8 b775 NMOSWRAP
VG776 g776 0 1.9061884908977569
RB776 b776 0 10
X776 39 g776 8 b776 NMOSWRAP
VG777 g777 0 1.9879156679744470
RB777 b777 0 10
X777 39 g777 9 b777 NMOSWRAP
VG778 g778 0 2.5563431909005083
RB778 b778 0 10
X778 39 g778 9 b778 NMOSWRAP
VG779 g779 0 2.6884699231060480
RB779 b779 0 10
X779 39 g779 9 b779 NMOSWRAP
VG780 g780 0 1.2781454022972256
RB780 b780 0 10
X780 39 g780 10 b780 NMOSWRAP
VG781 g781 0 1.8538087204221474
RB781 b781 0 10
X781 39 g781 10 b781 NMOSWRAP
VG782 g782 0 2.6857097756709143
RB782 b782 0 10
X782 39 g782 10 b782 NMOSWRAP
VG783 g783 0 2.6360666115116769
RB783 b783 0 10
X783 39 g783 11 b783 NMOSWRAP
VG784 g784 0 1.2048275169048328
RB784 b784 0 10
X784 39 g784 11 b784 NMOSWRAP
VG785 g785 0 1.3127666977359260
RB785 b785 0 10
X785 39 g785 11 b785 NMOSWRAP
VG786 g786 0 1.6083973831988156
RB786 b786 0 10
X786 39 g786 12 b786 NMOSWRAP
VG787 g787 0 1.1507181381666807
RB787 b787 0 10
X787 39 g787 12 b787 NMOSWRAP
VG788 g788 0 1.8493260056811858
RB788 b788 0 10
X788 39 g788 12 b788 NMOSWRAP
VG789 g789 0 1.2152354102991638
RB789 b789 0 10
X789 40 g789 3 b789 NMOSWRAP
VG790 g790 0 2.1364351873396901
RB790 b790 0 10
X790 40 g790 3 b790 NMOSWRAP
VG791 g791 0 1.4931138796223122
RB791 b791 0 10
X791 40 g791 3 b791 NMOSWRAP
VG792 g792 0 2.1928661306992456
RB792 b792 0 10
X792 40 g792 4 b792 NMOSWRAP
VG793 g793 0 1.2350512858072753
RB793 b793 0 10
X793 40 g793 4 b793 NMOSWRAP
VG794 g794 0 2.9517677368370667
RB794 b794 0 10
X794 40 g794 4 b794 NMOSWRAP
VG795 g795 0 2.8651224077146811
RB795 b795 0 10
X795 40 g795 5 b795 NMOSWRAP
VG796 g796 0 1.7835938771293316
RB796 b796 0 10
X796 40 g796 6 b796 NMOSWRAP
VG797 g797 0 1.4843571882521709
RB797 b797 0 10
X797 40 g797 6 b797 NMOSWRAP
VG798 g798 0 1.5007964257071456
RB798 b798 0 10
X798 40 g798 6 b798 NMOSWRAP
VG799 g799 0 1.9667870704047841
RB799 b799 0 10
X799 40 g799 7 b799 NMOSWRAP
VG800 g800 0 1.0799856038014339
RB800 b800 0 10
X800 40 g800 7 b800 NMOSWRAP
VG801 g801 0 2.2794102121502542
RB801 b801 0 10
X801 40 g801 7 b801 NMOSWRAP
VG802 g802 0 1.8166058166794896
RB802 b802 0 10
X802 40 g802 8 b802 NMOSWRAP
VG803 g803 0 1.7548131451777746
RB803 b803 0 10
X803 40 g803 8 b803 NMOSWRAP
VG804 g804 0 2.6187299429783968
RB804 b804 0 10
X804 40 g804 8 b804 NMOSWRAP
VG805 g805 0 2.4180709203665800
RB805 b805 0 10
X805 40 g805 9 b805 NMOSWRAP
VG806 g806 0 2.9086676307853843
RB806 b806 0 10
X806 40 g806 9 b806 NMOSWRAP
VG807 g807 0 1.7038724809913814
RB807 b807 0 10
X807 40 g807 9 b807 NMOSWRAP
VG808 g808 0 2.7950855292988113
RB808 b808 0 10
X808 40 g808 10 b808 NMOSWRAP
VG809 g809 0 2.5399343725001780
RB809 b809 0 10
X809 40 g809 10 b809 NMOSWRAP
VG810 g810 0 1.7148493031894261
RB810 b810 0 10
X810 40 g810 11 b810 NMOSWRAP
VG811 g811 0 2.2433308729065153
RB811 b811 0 10
X811 40 g811 11 b811 NMOSWRAP
VG812 g812 0 1.5771399153033911
RB812 b812 0 10
X812 40 g812 11 b812 NMOSWRAP
VG813 g813 0 2.7487998341496844
RB813 b813 0 10
X813 40 g813 12 b813 NMOSWRAP
VG814 g814 0 1.2248546344246225
RB814 b814 0 10
X814 40 g814 12 b814 NMOSWRAP
VG815 g815 0 1.4248687225880821
RB815 b815 0 10
X815 40 g815 12 b815 NMOSWRAP
VG816 g816 0 1.3660665841598423
RB816 b816 0 10
X816 41 g816 3 b816 NMOSWRAP
VG817 g817 0 1.8060520048085773
RB817 b817 0 10
X817 41 g817 4 b817 NMOSWRAP
VG818 g818 0 2.4904659200642580
RB818 b818 0 10
X818 41 g818 4 b818 NMOSWRAP
VG819 g819 0 2.0538148981043607
RB819 b819 0 10
X819 41 g819 4 b819 NMOSWRAP
VG820 g820 0 1.9753526470764151
RB820 b820 0 10
X820 41 g820 5 b820 NMOSWRAP
VG821 g821 0 1.0010919297939913
RB821 b821 0 10
X821 41 g821 5 b821 NMOSWRAP
VG822 g822 0 1.8508034507101094
RB822 b822 0 10
X822 41 g822 5 b822 NMOSWRAP
VG823 g823 0 1.1271075496723169
RB823 b823 0 10
X823 41 g823 6 b823 NMOSWRAP
VG824 g824 0 1.4165065042429676
RB824 b824 0 10
X824 41 g824 6 b824 NMOSWRAP
VG825 g825 0 2.8647878779209890
RB825 b825 0 10
X825 41 g825 6 b825 NMOSWRAP
VG826 g826 0 1.4307964086864764
RB826 b826 0 10
X826 41 g826 7 b826 NMOSWRAP
VG827 g827 0 2.7166752772685250
RB827 b827 0 10
X827 41 g827 7 b827 NMOSWRAP
VG828 g828 0 2.6057867431226684
RB828 b828 0 10
X828 41 g828 7 b828 NMOSWRAP
VG829 g829 0 1.3182924738844857
RB829 b829 0 10
X829 41 g829 8 b829 NMOSWRAP
VG830 g830 0 2.2114239145405579
RB830 b830 0 10
X830 41 g830 8 b830 NMOSWRAP
VG831 g831 0 1.2313237438100266
RB831 b831 0 10
X831 41 g831 8 b831 NMOSWRAP
VG832 g832 0 2.4557763167390227
RB832 b832 0 10
X832 41 g832 9 b832 NMOSWRAP
VG833 g833 0 2.2749245547444135
RB833 b833 0 10
X833 41 g833 9 b833 NMOSWRAP
VG834 g834 0 2.6238771233820386
RB834 b834 0 10
X834 41 g834 9 b834 NMOSWRAP
VG835 g835 0 1.9587690987783761
RB835 b835 0 10
X835 41 g835 10 b835 NMOSWRAP
VG836 g836 0 2.8297261756667655
RB836 b836 0 10
X836 41 g836 10 b836 NMOSWRAP
VG837 g837 0 1.0986978935768794
RB837 b837 0 10
X837 41 g837 10 b837 NMOSWRAP
VG838 g838 0 1.5857771300540293
RB838 b838 0 10
X838 41 g838 11 b838 NMOSWRAP
VG839 g839 0 2.4301051949303343
RB839 b839 0 10
X839 41 g839 11 b839 NMOSWRAP
VG840 g840 0 1.8362184234960017
RB840 b840 0 10
X840 41 g840 11 b840 NMOSWRAP
VG841 g841 0 1.3459027085423128
RB841 b841 0 10
X841 41 g841 12 b841 NMOSWRAP
VG842 g842 0 1.2144214908570921
RB842 b842 0 10
X842 41 g842 12 b842 NMOSWRAP
VG843 g843 0 2.6346782229232426
RB843 b843 0 10
X843 41 g843 12 b843 NMOSWRAP
VG844 g844 0 1.9462859569312885
RB844 b844 0 10
X844 42 g844 3 b844 NMOSWRAP
VG845 g845 0 2.7645673438382148
RB845 b845 0 10
X845 42 g845 3 b845 NMOSWRAP
VG846 g846 0 2.4665782686334521
RB846 b846 0 10
X846 42 g846 3 b846 NMOSWRAP
VG847 g847 0 1.8194524112614872
RB847 b847 0 10
X847 42 g847 4 b847 NMOSWRAP
VG848 g848 0 1.7470220283113673
RB848 b848 0 10
X848 42 g848 4 b848 NMOSWRAP
VG849 g849 0 2.0312766933025035
RB849 b849 0 10
X849 42 g849 4 b849 NMOSWRAP
VG850 g850 0 2.7781199063794570
RB850 b850 0 10
X850 42 g850 5 b850 NMOSWRAP
VG851 g851 0 2.4745571594283358
RB851 b851 0 10
X851 42 g851 5 b851 NMOSWRAP
VG852 g852 0 1.0103059285380465
RB852 b852 0 10
X852 42 g852 5 b852 NMOSWRAP
VG853 g853 0 2.3883157027382511
RB853 b853 0 10
X853 42 g853 6 b853 NMOSWRAP
VG854 g854 0 2.8390148138116413
RB854 b854 0 10
X854 42 g854 6 b854 NMOSWRAP
VG855 g855 0 2.4209115190089832
RB855 b855 0 10
X855 42 g855 7 b855 NMOSWRAP
VG856 g856 0 1.3540115631349918
RB856 b856 0 10
X856 42 g856 7 b856 NMOSWRAP
VG857 g857 0 1.9670362548549174
RB857 b857 0 10
X857 42 g857 7 b857 NMOSWRAP
VG858 g858 0 1.2806320358468388
RB858 b858 0 10
X858 42 g858 8 b858 NMOSWRAP
VG859 g859 0 1.7179905566792641
RB859 b859 0 10
X859 42 g859 8 b859 NMOSWRAP
VG860 g860 0 2.8742340838810354
RB860 b860 0 10
X860 42 g860 8 b860 NMOSWRAP
VG861 g861 0 2.8466106151174166
RB861 b861 0 10
X861 42 g861 9 b861 NMOSWRAP
VG862 g862 0 1.5656737043521658
RB862 b862 0 10
X862 42 g862 9 b862 NMOSWRAP
VG863 g863 0 1.6792620883323983
RB863 b863 0 10
X863 42 g863 9 b863 NMOSWRAP
VG864 g864 0 2.2004257362625879
RB864 b864 0 10
X864 42 g864 10 b864 NMOSWRAP
VG865 g865 0 2.9263945905207600
RB865 b865 0 10
X865 42 g865 10 b865 NMOSWRAP
VG866 g866 0 1.2956026681307808
RB866 b866 0 10
X866 42 g866 10 b866 NMOSWRAP
VG867 g867 0 1.5138332873733382
RB867 b867 0 10
X867 42 g867 11 b867 NMOSWRAP
VG868 g868 0 2.7471136545815429
RB868 b868 0 10
X868 42 g868 11 b868 NMOSWRAP
VG869 g869 0 1.9837844634166890
RB869 b869 0 10
X869 42 g869 11 b869 NMOSWRAP
VG870 g870 0 2.7979221844540634
RB870 b870 0 10
X870 42 g870 12 b870 NMOSWRAP
VG871 g871 0 1.3710357950463525
RB871 b871 0 10
X871 42 g871 12 b871 NMOSWRAP
VG872 g872 0 2.0653371749427212
RB872 b872 0 10
X872 42 g872 12 b872 NMOSWRAP
VG873 g873 0 1.6525392652987447
RB873 b873 0 10
X873 43 g873 3 b873 NMOSWRAP
VG874 g874 0 1.6330851197849521
RB874 b874 0 10
X874 43 g874 3 b874 NMOSWRAP
VG875 g875 0 1.8937539278923983
RB875 b875 0 10
X875 43 g875 3 b875 NMOSWRAP
VG876 g876 0 1.8661548982025369
RB876 b876 0 10
X876 43 g876 4 b876 NMOSWRAP
VG877 g877 0 1.7146937593559088
RB877 b877 0 10
X877 43 g877 4 b877 NMOSWRAP
VG878 g878 0 2.8299415406312374
RB878 b878 0 10
X878 43 g878 4 b878 NMOSWRAP
VG879 g879 0 2.4634883708657855
RB879 b879 0 10
X879 43 g879 5 b879 NMOSWRAP
VG880 g880 0 2.4550939826630591
RB880 b880 0 10
X880 43 g880 5 b880 NMOSWRAP
VG881 g881 0 1.5798268991839108
RB881 b881 0 10
X881 43 g881 5 b881 NMOSWRAP
VG882 g882 0 2.1554188486336807
RB882 b882 0 10
X882 43 g882 6 b882 NMOSWRAP
VG883 g883 0 2.5583588666036681
RB883 b883 0 10
X883 43 g883 6 b883 NMOSWRAP
VG884 g884 0 2.5911807370864262
RB884 b884 0 10
X884 43 g884 7 b884 NMOSWRAP
VG885 g885 0 1.6890609215086245
RB885 b885 0 10
X885 43 g885 7 b885 NMOSWRAP
VG886 g886 0 2.5417455131372959
RB886 b886 0 10
X886 43 g886 7 b886 NMOSWRAP
VG887 g887 0 2.4717877936154657
RB887 b887 0 10
X887 43 g887 8 b887 NMOSWRAP
VG888 g888 0 1.2830129712438005
RB888 b888 0 10
X888 43 g888 8 b888 NMOSWRAP
VG889 g889 0 2.7318909371329543
RB889 b889 0 10
X889 43 g889 8 b889 NMOSWRAP
VG890 g890 0 1.8826429403608216
RB890 b890 0 10
X890 43 g890 9 b890 NMOSWRAP
VG891 g891 0 1.9728208977773309
RB891 b891 0 10
X891 43 g891 9 b891 NMOSWRAP
VG892 g892 0 1.8967383577959946
RB892 b892 0 10
X892 43 g892 9 b892 NMOSWRAP
VG893 g893 0 2.1356920029550150
RB893 b893 0 10
X893 43 g893 10 b893 NMOSWRAP
VG894 g894 0 2.2423384947341094
RB894 b894 0 10
X894 43 g894 10 b894 NMOSWRAP
VG895 g895 0 1.9963591315258868
RB895 b895 0 10
X895 43 g895 10 b895 NMOSWRAP
VG896 g896 0 2.7335770865181912
RB896 b896 0 10
X896 43 g896 11 b896 NMOSWRAP
VG897 g897 0 2.2554695123905688
RB897 b897 0 10
X897 43 g897 11 b897 NMOSWRAP
VG898 g898 0 1.8028558986110399
RB898 b898 0 10
X898 43 g898 11 b898 NMOSWRAP
VG899 g899 0 1.8333835138174219
RB899 b899 0 10
X899 43 g899 12 b899 NMOSWRAP
VG900 g900 0 2.6216772302579026
RB900 b900 0 10
X900 43 g900 12 b900 NMOSWRAP
VG901 g901 0 1.6963838854930402
RB901 b901 0 10
X901 43 g901 12 b901 NMOSWRAP
VG902 g902 0 1.4229095915648271
RB902 b902 0 10
X902 44 g902 3 b902 NMOSWRAP
VG903 g903 0 1.1187663760115785
RB903 b903 0 10
X903 44 g903 3 b903 NMOSWRAP
VG904 g904 0 2.7520536958411483
RB904 b904 0 10
X904 44 g904 3 b904 NMOSWRAP
VG905 g905 0 2.8370929023807001
RB905 b905 0 10
X905 44 g905 4 b905 NMOSWRAP
VG906 g906 0 1.2402403643269519
RB906 b906 0 10
X906 44 g906 4 b906 NMOSWRAP
VG907 g907 0 1.6689474829922297
RB907 b907 0 10
X907 44 g907 4 b907 NMOSWRAP
VG908 g908 0 1.3507441390304877
RB908 b908 0 10
X908 44 g908 5 b908 NMOSWRAP
VG909 g909 0 1.2317969376517595
RB909 b909 0 10
X909 44 g909 5 b909 NMOSWRAP
VG910 g910 0 2.7997334860000604
RB910 b910 0 10
X910 44 g910 5 b910 NMOSWRAP
VG911 g911 0 1.1137545182907109
RB911 b911 0 10
X911 44 g911 6 b911 NMOSWRAP
VG912 g912 0 2.9609713269380133
RB912 b912 0 10
X912 44 g912 6 b912 NMOSWRAP
VG913 g913 0 1.1929017213947684
RB913 b913 0 10
X913 44 g913 6 b913 NMOSWRAP
VG914 g914 0 2.7269412983871715
RB914 b914 0 10
X914 44 g914 7 b914 NMOSWRAP
VG915 g915 0 2.1330122139783256
RB915 b915 0 10
X915 44 g915 7 b915 NMOSWRAP
VG916 g916 0 1.7358349756357467
RB916 b916 0 10
X916 44 g916 7 b916 NMOSWRAP
VG917 g917 0 1.6846847532503157
RB917 b917 0 10
X917 44 g917 8 b917 NMOSWRAP
VG918 g918 0 2.5147282864754175
RB918 b918 0 10
X918 44 g918 8 b918 NMOSWRAP
VG919 g919 0 1.6291465900085744
RB919 b919 0 10
X919 44 g919 8 b919 NMOSWRAP
VG920 g920 0 2.3146378332342836
RB920 b920 0 10
X920 44 g920 9 b920 NMOSWRAP
VG921 g921 0 2.0346521670321600
RB921 b921 0 10
X921 44 g921 9 b921 NMOSWRAP
VG922 g922 0 1.9699312903161410
RB922 b922 0 10
X922 44 g922 9 b922 NMOSWRAP
VG923 g923 0 2.8023243412983234
RB923 b923 0 10
X923 44 g923 10 b923 NMOSWRAP
VG924 g924 0 2.1092901172405192
RB924 b924 0 10
X924 44 g924 10 b924 NMOSWRAP
VG925 g925 0 2.6537232060973901
RB925 b925 0 10
X925 44 g925 10 b925 NMOSWRAP
VG926 g926 0 2.4511470682029790
RB926 b926 0 10
X926 44 g926 11 b926 NMOSWRAP
VG927 g927 0 1.0771144921179967
RB927 b927 0 10
X927 44 g927 11 b927 NMOSWRAP
VG928 g928 0 2.5462201050108382
RB928 b928 0 10
X928 44 g928 11 b928 NMOSWRAP
VG929 g929 0 1.4337405001820813
RB929 b929 0 10
X929 44 g929 12 b929 NMOSWRAP
VG930 g930 0 2.8062992937031428
RB930 b930 0 10
X930 44 g930 12 b930 NMOSWRAP
VG931 g931 0 1.0858483812176640
RB931 b931 0 10
X931 44 g931 12 b931 NMOSWRAP
VG932 g932 0 1.6661440689486375
RB932 b932 0 10
X932 45 g932 3 b932 NMOSWRAP
VG933 g933 0 1.1994658944695080
RB933 b933 0 10
X933 45 g933 3 b933 NMOSWRAP
VG934 g934 0 1.9511782341696875
RB934 b934 0 10
X934 45 g934 3 b934 NMOSWRAP
VG935 g935 0 2.6400448717395033
RB935 b935 0 10
X935 45 g935 4 b935 NMOSWRAP
VG936 g936 0 1.5963747193261282
RB936 b936 0 10
X936 45 g936 4 b936 NMOSWRAP
VG937 g937 0 1.3018697946220832
RB937 b937 0 10
X937 45 g937 4 b937 NMOSWRAP
VG938 g938 0 1.6605340713937984
RB938 b938 0 10
X938 45 g938 5 b938 NMOSWRAP
VG939 g939 0 2.6277602838412717
RB939 b939 0 10
X939 45 g939 5 b939 NMOSWRAP
VG940 g940 0 1.2807679155986937
RB940 b940 0 10
X940 45 g940 5 b940 NMOSWRAP
VG941 g941 0 1.4547248981550036
RB941 b941 0 10
X941 45 g941 6 b941 NMOSWRAP
VG942 g942 0 1.1377039289867479
RB942 b942 0 10
X942 45 g942 6 b942 NMOSWRAP
VG943 g943 0 2.4114200879792156
RB943 b943 0 10
X943 45 g943 6 b943 NMOSWRAP
VG944 g944 0 1.7904664870726736
RB944 b944 0 10
X944 45 g944 7 b944 NMOSWRAP
VG945 g945 0 1.6216799542866320
RB945 b945 0 10
X945 45 g945 7 b945 NMOSWRAP
VG946 g946 0 2.4372527806823037
RB946 b946 0 10
X946 45 g946 7 b946 NMOSWRAP
VG947 g947 0 1.6719550846805105
RB947 b947 0 10
X947 45 g947 8 b947 NMOSWRAP
VG948 g948 0 2.4555425464288358
RB948 b948 0 10
X948 45 g948 8 b948 NMOSWRAP
VG949 g949 0 2.6303987906286270
RB949 b949 0 10
X949 45 g949 8 b949 NMOSWRAP
VG950 g950 0 1.4353256869154769
RB950 b950 0 10
X950 45 g950 9 b950 NMOSWRAP
VG951 g951 0 2.9476373936919664
RB951 b951 0 10
X951 45 g951 9 b951 NMOSWRAP
VG952 g952 0 1.3247158958253336
RB952 b952 0 10
X952 45 g952 9 b952 NMOSWRAP
VG953 g953 0 1.5816818133134851
RB953 b953 0 10
X953 45 g953 10 b953 NMOSWRAP
VG954 g954 0 1.3595905816670832
RB954 b954 0 10
X954 45 g954 10 b954 NMOSWRAP
VG955 g955 0 1.6910113127126689
RB955 b955 0 10
X955 45 g955 10 b955 NMOSWRAP
VG956 g956 0 1.9601217756415112
RB956 b956 0 10
X956 45 g956 11 b956 NMOSWRAP
VG957 g957 0 2.0443517380042380
RB957 b957 0 10
X957 45 g957 11 b957 NMOSWRAP
VG958 g958 0 2.7072120845925438
RB958 b958 0 10
X958 45 g958 11 b958 NMOSWRAP
VG959 g959 0 2.7788958176317333
RB959 b959 0 10
X959 45 g959 12 b959 NMOSWRAP
VG960 g960 0 1.4402077215618128
RB960 b960 0 10
X960 45 g960 12 b960 NMOSWRAP
VG961 g961 0 2.2457880643715047
RB961 b961 0 10
X961 45 g961 12 b961 NMOSWRAP
VG962 g962 0 1.2229921145974312
RB962 b962 0 10
X962 46 g962 3 b962 NMOSWRAP
VG963 g963 0 1.9179397203641366
RB963 b963 0 10
X963 46 g963 3 b963 NMOSWRAP
VG964 g964 0 1.6446670760932363
RB964 b964 0 10
X964 46 g964 3 b964 NMOSWRAP
VG965 g965 0 1.6330014909072128
RB965 b965 0 10
X965 46 g965 4 b965 NMOSWRAP
VG966 g966 0 1.9651684834242020
RB966 b966 0 10
X966 46 g966 4 b966 NMOSWRAP
VG967 g967 0 2.4596552710585353
RB967 b967 0 10
X967 46 g967 4 b967 NMOSWRAP
VG968 g968 0 1.1383653175847790
RB968 b968 0 10
X968 46 g968 5 b968 NMOSWRAP
VG969 g969 0 2.7583466753748089
RB969 b969 0 10
X969 46 g969 5 b969 NMOSWRAP
VG970 g970 0 2.4696275492611219
RB970 b970 0 10
X970 46 g970 5 b970 NMOSWRAP
VG971 g971 0 1.3529987777781203
RB971 b971 0 10
X971 46 g971 6 b971 NMOSWRAP
VG972 g972 0 2.8783218181747410
RB972 b972 0 10
X972 46 g972 6 b972 NMOSWRAP
VG973 g973 0 2.0126244480467772
RB973 b973 0 10
X973 46 g973 6 b973 NMOSWRAP
VG974 g974 0 2.9996171562339304
RB974 b974 0 10
X974 46 g974 7 b974 NMOSWRAP
VG975 g975 0 1.3945189486014753
RB975 b975 0 10
X975 46 g975 7 b975 NMOSWRAP
VG976 g976 0 2.0698163967664027
RB976 b976 0 10
X976 46 g976 7 b976 NMOSWRAP
VG977 g977 0 1.5804960851198568
RB977 b977 0 10
X977 46 g977 8 b977 NMOSWRAP
VG978 g978 0 1.6083471147784931
RB978 b978 0 10
X978 46 g978 8 b978 NMOSWRAP
VG979 g979 0 2.1821307616679801
RB979 b979 0 10
X979 46 g979 8 b979 NMOSWRAP
VG980 g980 0 2.8434381337416665
RB980 b980 0 10
X980 46 g980 9 b980 NMOSWRAP
VG981 g981 0 2.6105277111583503
RB981 b981 0 10
X981 46 g981 9 b981 NMOSWRAP
VG982 g982 0 2.4478827970026518
RB982 b982 0 10
X982 46 g982 9 b982 NMOSWRAP
VG983 g983 0 2.1183475642034044
RB983 b983 0 10
X983 46 g983 10 b983 NMOSWRAP
VG984 g984 0 2.8445970073348956
RB984 b984 0 10
X984 46 g984 10 b984 NMOSWRAP
VG985 g985 0 1.9847228133817683
RB985 b985 0 10
X985 46 g985 10 b985 NMOSWRAP
VG986 g986 0 2.7476643566694365
RB986 b986 0 10
X986 46 g986 11 b986 NMOSWRAP
VG987 g987 0 2.6679632877532633
RB987 b987 0 10
X987 46 g987 11 b987 NMOSWRAP
VG988 g988 0 1.4276706936031731
RB988 b988 0 10
X988 46 g988 11 b988 NMOSWRAP
VG989 g989 0 2.5424509259318206
RB989 b989 0 10
X989 46 g989 12 b989 NMOSWRAP
VG990 g990 0 1.0243423138865175
RB990 b990 0 10
X990 46 g990 12 b990 NMOSWRAP
VG991 g991 0 1.6456590750961750
RB991 b991 0 10
X991 46 g991 12 b991 NMOSWRAP
VG992 g992 0 1.4591348893838996
RB992 b992 0 10
X992 47 g992 3 b992 NMOSWRAP
VG993 g993 0 2.0137259169746269
RB993 b993 0 10
X993 47 g993 3 b993 NMOSWRAP
VG994 g994 0 2.4737063233615713
RB994 b994 0 10
X994 47 g994 3 b994 NMOSWRAP
VG995 g995 0 1.1953527348954482
RB995 b995 0 10
X995 47 g995 4 b995 NMOSWRAP
VG996 g996 0 2.0298444038735370
RB996 b996 0 10
X996 47 g996 4 b996 NMOSWRAP
VG997 g997 0 2.8768240433887713
RB997 b997 0 10
X997 47 g997 4 b997 NMOSWRAP
VG998 g998 0 1.4572931019658910
RB998 b998 0 10
X998 47 g998 5 b998 NMOSWRAP
VG999 g999 0 2.3542822882228482
RB999 b999 0 10
X999 47 g999 5 b999 NMOSWRAP
VG1000 g1000 0 2.1857605415623151
RB1000 b1000 0 10
X1000 47 g1000 6 b1000 NMOSWRAP
VG1001 g1001 0 1.0201273913121867
RB1001 b1001 0 10
X1001 47 g1001 6 b1001 NMOSWRAP
VG1002 g1002 0 1.9516523917144455
RB1002 b1002 0 10
X1002 47 g1002 6 b1002 NMOSWRAP
VG1003 g1003 0 2.4175407818820975
RB1003 b1003 0 10
X1003 47 g1003 7 b1003 NMOSWRAP
VG1004 g1004 0 1.0879508640481812
RB1004 b1004 0 10
X1004 47 g1004 7 b1004 NMOSWRAP
VG1005 g1005 0 2.7590429660474602
RB1005 b1005 0 10
X1005 47 g1005 7 b1005 NMOSWRAP
VG1006 g1006 0 2.0401628332713462
RB1006 b1006 0 10
X1006 47 g1006 8 b1006 NMOSWRAP
VG1007 g1007 0 1.0613220966514358
RB1007 b1007 0 10
X1007 47 g1007 8 b1007 NMOSWRAP
VG1008 g1008 0 1.4488272238416804
RB1008 b1008 0 10
X1008 47 g1008 8 b1008 NMOSWRAP
VG1009 g1009 0 2.9073513928546260
RB1009 b1009 0 10
X1009 47 g1009 9 b1009 NMOSWRAP
VG1010 g1010 0 2.1646394661041106
RB1010 b1010 0 10
X1010 47 g1010 9 b1010 NMOSWRAP
VG1011 g1011 0 1.2149451355376091
RB1011 b1011 0 10
X1011 47 g1011 9 b1011 NMOSWRAP
VG1012 g1012 0 1.5750890045611230
RB1012 b1012 0 10
X1012 47 g1012 10 b1012 NMOSWRAP
VG1013 g1013 0 1.9134072517209684
RB1013 b1013 0 10
X1013 47 g1013 10 b1013 NMOSWRAP
VG1014 g1014 0 1.0419001385354609
RB1014 b1014 0 10
X1014 47 g1014 10 b1014 NMOSWRAP
VG1015 g1015 0 1.8232310272275176
RB1015 b1015 0 10
X1015 47 g1015 11 b1015 NMOSWRAP
VG1016 g1016 0 1.9789172708693963
RB1016 b1016 0 10
X1016 47 g1016 11 b1016 NMOSWRAP
VG1017 g1017 0 1.4873557505624644
RB1017 b1017 0 10
X1017 47 g1017 11 b1017 NMOSWRAP
VG1018 g1018 0 2.1772780005839731
RB1018 b1018 0 10
X1018 47 g1018 12 b1018 NMOSWRAP
VG1019 g1019 0 2.5064802391843539
RB1019 b1019 0 10
X1019 47 g1019 12 b1019 NMOSWRAP
VG1020 g1020 0 1.4716684482112710
RB1020 b1020 0 10
X1020 47 g1020 12 b1020 NMOSWRAP
VG1021 g1021 0 2.2409998005599752
RB1021 b1021 0 10
X1021 48 g1021 3 b1021 NMOSWRAP
VG1022 g1022 0 2.2792444859274834
RB1022 b1022 0 10
X1022 48 g1022 3 b1022 NMOSWRAP
VG1023 g1023 0 2.8970806022576818
RB1023 b1023 0 10
X1023 48 g1023 4 b1023 NMOSWRAP
VG1024 g1024 0 2.5565523345928876
RB1024 b1024 0 10
X1024 48 g1024 4 b1024 NMOSWRAP
VG1025 g1025 0 2.6966905395800120
RB1025 b1025 0 10
X1025 48 g1025 4 b1025 NMOSWRAP
VG1026 g1026 0 1.9808398168725503
RB1026 b1026 0 10
X1026 48 g1026 5 b1026 NMOSWRAP
VG1027 g1027 0 1.3706971739587657
RB1027 b1027 0 10
X1027 48 g1027 5 b1027 NMOSWRAP
VG1028 g1028 0 2.9916305859192702
RB1028 b1028 0 10
X1028 48 g1028 5 b1028 NMOSWRAP
VG1029 g1029 0 1.2587115220773992
RB1029 b1029 0 10
X1029 48 g1029 6 b1029 NMOSWRAP
VG1030 g1030 0 1.9429146387085308
RB1030 b1030 0 10
X1030 48 g1030 6 b1030 NMOSWRAP
VG1031 g1031 0 1.1361861984842132
RB1031 b1031 0 10
X1031 48 g1031 6 b1031 NMOSWRAP
VG1032 g1032 0 2.8877017147016391
RB1032 b1032 0 10
X1032 48 g1032 7 b1032 NMOSWRAP
VG1033 g1033 0 2.9298498816968790
RB1033 b1033 0 10
X1033 48 g1033 7 b1033 NMOSWRAP
VG1034 g1034 0 2.4387781240079471
RB1034 b1034 0 10
X1034 48 g1034 7 b1034 NMOSWRAP
VG1035 g1035 0 1.6999856872603378
RB1035 b1035 0 10
X1035 48 g1035 8 b1035 NMOSWRAP
VG1036 g1036 0 1.5087648022352487
RB1036 b1036 0 10
X1036 48 g1036 8 b1036 NMOSWRAP
VG1037 g1037 0 1.5306066490740948
RB1037 b1037 0 10
X1037 48 g1037 8 b1037 NMOSWRAP
VG1038 g1038 0 1.2545880508401495
RB1038 b1038 0 10
X1038 48 g1038 9 b1038 NMOSWRAP
VG1039 g1039 0 2.0516179061534459
RB1039 b1039 0 10
X1039 48 g1039 9 b1039 NMOSWRAP
VG1040 g1040 0 1.2836345514029550
RB1040 b1040 0 10
X1040 48 g1040 9 b1040 NMOSWRAP
VG1041 g1041 0 1.6334613331069125
RB1041 b1041 0 10
X1041 48 g1041 10 b1041 NMOSWRAP
VG1042 g1042 0 2.2534129519182100
RB1042 b1042 0 10
X1042 48 g1042 10 b1042 NMOSWRAP
VG1043 g1043 0 2.4550872191814994
RB1043 b1043 0 10
X1043 48 g1043 10 b1043 NMOSWRAP
VG1044 g1044 0 1.0485454092441224
RB1044 b1044 0 10
X1044 48 g1044 11 b1044 NMOSWRAP
VG1045 g1045 0 1.8602319687534798
RB1045 b1045 0 10
X1045 48 g1045 11 b1045 NMOSWRAP
VG1046 g1046 0 2.3042491896842781
RB1046 b1046 0 10
X1046 48 g1046 11 b1046 NMOSWRAP
VG1047 g1047 0 2.7064919523170259
RB1047 b1047 0 10
X1047 48 g1047 12 b1047 NMOSWRAP
VG1048 g1048 0 1.9506495644241648
RB1048 b1048 0 10
X1048 48 g1048 12 b1048 NMOSWRAP
VG1049 g1049 0 2.9384117434353705
RB1049 b1049 0 10
X1049 48 g1049 12 b1049 NMOSWRAP
VG1050 g1050 0 1.5312650950828945
RB1050 b1050 0 10
X1050 49 g1050 3 b1050 NMOSWRAP
VG1051 g1051 0 1.0270174132534378
RB1051 b1051 0 10
X1051 49 g1051 3 b1051 NMOSWRAP
VG1052 g1052 0 1.9675057294034723
RB1052 b1052 0 10
X1052 49 g1052 4 b1052 NMOSWRAP
VG1053 g1053 0 1.5122275900400359
RB1053 b1053 0 10
X1053 49 g1053 4 b1053 NMOSWRAP
VG1054 g1054 0 2.6474353440463387
RB1054 b1054 0 10
X1054 49 g1054 4 b1054 NMOSWRAP
VG1055 g1055 0 1.4655453443622242
RB1055 b1055 0 10
X1055 49 g1055 5 b1055 NMOSWRAP
VG1056 g1056 0 1.6212584365826126
RB1056 b1056 0 10
X1056 49 g1056 5 b1056 NMOSWRAP
VG1057 g1057 0 2.5824548620382246
RB1057 b1057 0 10
X1057 49 g1057 5 b1057 NMOSWRAP
VG1058 g1058 0 2.4302865040507200
RB1058 b1058 0 10
X1058 49 g1058 6 b1058 NMOSWRAP
VG1059 g1059 0 2.1161024733145251
RB1059 b1059 0 10
X1059 49 g1059 6 b1059 NMOSWRAP
VG1060 g1060 0 2.4098961238455190
RB1060 b1060 0 10
X1060 49 g1060 6 b1060 NMOSWRAP
VG1061 g1061 0 1.8372737271400530
RB1061 b1061 0 10
X1061 49 g1061 7 b1061 NMOSWRAP
VG1062 g1062 0 1.0106200952293356
RB1062 b1062 0 10
X1062 49 g1062 7 b1062 NMOSWRAP
VG1063 g1063 0 1.0227102570243851
RB1063 b1063 0 10
X1063 49 g1063 7 b1063 NMOSWRAP
VG1064 g1064 0 2.0224435751473733
RB1064 b1064 0 10
X1064 49 g1064 8 b1064 NMOSWRAP
VG1065 g1065 0 1.1665819594379985
RB1065 b1065 0 10
X1065 49 g1065 8 b1065 NMOSWRAP
VG1066 g1066 0 1.1021509603385136
RB1066 b1066 0 10
X1066 49 g1066 9 b1066 NMOSWRAP
VG1067 g1067 0 2.9310332782749464
RB1067 b1067 0 10
X1067 49 g1067 9 b1067 NMOSWRAP
VG1068 g1068 0 2.7180052793161171
RB1068 b1068 0 10
X1068 49 g1068 9 b1068 NMOSWRAP
VG1069 g1069 0 1.3040544544191390
RB1069 b1069 0 10
X1069 49 g1069 10 b1069 NMOSWRAP
VG1070 g1070 0 1.0013284371804090
RB1070 b1070 0 10
X1070 49 g1070 10 b1070 NMOSWRAP
VG1071 g1071 0 2.8833355907795131
RB1071 b1071 0 10
X1071 49 g1071 10 b1071 NMOSWRAP
VG1072 g1072 0 1.5566505966402286
RB1072 b1072 0 10
X1072 49 g1072 11 b1072 NMOSWRAP
VG1073 g1073 0 1.3717952057109950
RB1073 b1073 0 10
X1073 49 g1073 11 b1073 NMOSWRAP
VG1074 g1074 0 2.3830162156630705
RB1074 b1074 0 10
X1074 49 g1074 11 b1074 NMOSWRAP
VG1075 g1075 0 1.2178074776826524
RB1075 b1075 0 10
X1075 49 g1075 12 b1075 NMOSWRAP
VG1076 g1076 0 1.5292991960056006
RB1076 b1076 0 10
X1076 49 g1076 12 b1076 NMOSWRAP
VG1077 g1077 0 2.9501893604240932
RB1077 b1077 0 10
X1077 50 g1077 3 b1077 NMOSWRAP
VG1078 g1078 0 2.2789255489480205
RB1078 b1078 0 10
X1078 50 g1078 3 b1078 NMOSWRAP
VG1079 g1079 0 2.0413555829651071
RB1079 b1079 0 10
X1079 50 g1079 3 b1079 NMOSWRAP
VG1080 g1080 0 1.7958372296698755
RB1080 b1080 0 10
X1080 50 g1080 4 b1080 NMOSWRAP
VG1081 g1081 0 2.5490019097684042
RB1081 b1081 0 10
X1081 50 g1081 4 b1081 NMOSWRAP
VG1082 g1082 0 1.2819149530473875
RB1082 b1082 0 10
X1082 50 g1082 4 b1082 NMOSWRAP
VG1083 g1083 0 2.9346756040739645
RB1083 b1083 0 10
X1083 50 g1083 5 b1083 NMOSWRAP
VG1084 g1084 0 2.7222460161315736
RB1084 b1084 0 10
X1084 50 g1084 5 b1084 NMOSWRAP
VG1085 g1085 0 2.2353139651384866
RB1085 b1085 0 10
X1085 50 g1085 6 b1085 NMOSWRAP
VG1086 g1086 0 1.0858123808051163
RB1086 b1086 0 10
X1086 50 g1086 6 b1086 NMOSWRAP
VG1087 g1087 0 2.4017112988954752
RB1087 b1087 0 10
X1087 50 g1087 6 b1087 NMOSWRAP
VG1088 g1088 0 2.8265686817709614
RB1088 b1088 0 10
X1088 50 g1088 7 b1088 NMOSWRAP
VG1089 g1089 0 2.0491541349572522
RB1089 b1089 0 10
X1089 50 g1089 7 b1089 NMOSWRAP
VG1090 g1090 0 1.7084496436545256
RB1090 b1090 0 10
X1090 50 g1090 7 b1090 NMOSWRAP
VG1091 g1091 0 1.2405546899589392
RB1091 b1091 0 10
X1091 50 g1091 8 b1091 NMOSWRAP
VG1092 g1092 0 2.5098022082751363
RB1092 b1092 0 10
X1092 50 g1092 8 b1092 NMOSWRAP
VG1093 g1093 0 2.7700437024236124
RB1093 b1093 0 10
X1093 50 g1093 8 b1093 NMOSWRAP
VG1094 g1094 0 1.2005034881516972
RB1094 b1094 0 10
X1094 50 g1094 9 b1094 NMOSWRAP
VG1095 g1095 0 2.5179691095046839
RB1095 b1095 0 10
X1095 50 g1095 9 b1095 NMOSWRAP
VG1096 g1096 0 1.0341209725181950
RB1096 b1096 0 10
X1096 50 g1096 9 b1096 NMOSWRAP
VG1097 g1097 0 2.9341098361544393
RB1097 b1097 0 10
X1097 50 g1097 10 b1097 NMOSWRAP
VG1098 g1098 0 2.2301160412701924
RB1098 b1098 0 10
X1098 50 g1098 10 b1098 NMOSWRAP
VG1099 g1099 0 2.1048781179832661
RB1099 b1099 0 10
X1099 50 g1099 10 b1099 NMOSWRAP
VG1100 g1100 0 1.5918996671778556
RB1100 b1100 0 10
X1100 50 g1100 11 b1100 NMOSWRAP
VG1101 g1101 0 2.8585833431395669
RB1101 b1101 0 10
X1101 50 g1101 11 b1101 NMOSWRAP
VG1102 g1102 0 1.5318112546735820
RB1102 b1102 0 10
X1102 50 g1102 11 b1102 NMOSWRAP
VG1103 g1103 0 2.6562932264333901
RB1103 b1103 0 10
X1103 50 g1103 12 b1103 NMOSWRAP
VG1104 g1104 0 2.9702173586742640
RB1104 b1104 0 10
X1104 50 g1104 12 b1104 NMOSWRAP
VG1105 g1105 0 2.5667932910296116
RB1105 b1105 0 10
X1105 50 g1105 12 b1105 NMOSWRAP
VG1106 g1106 0 2.0379798407728638
RB1106 b1106 0 10
X1106 51 g1106 3 b1106 NMOSWRAP
VG1107 g1107 0 1.1321485277033438
RB1107 b1107 0 10
X1107 51 g1107 3 b1107 NMOSWRAP
VG1108 g1108 0 1.9448275783421460
RB1108 b1108 0 10
X1108 51 g1108 3 b1108 NMOSWRAP
VG1109 g1109 0 1.8765118939434071
RB1109 b1109 0 10
X1109 51 g1109 4 b1109 NMOSWRAP
VG1110 g1110 0 1.4055920823739905
RB1110 b1110 0 10
X1110 51 g1110 4 b1110 NMOSWRAP
VG1111 g1111 0 1.8471752734286089
RB1111 b1111 0 10
X1111 51 g1111 4 b1111 NMOSWRAP
VG1112 g1112 0 1.7155157681606774
RB1112 b1112 0 10
X1112 51 g1112 5 b1112 NMOSWRAP
VG1113 g1113 0 1.3273685223032969
RB1113 b1113 0 10
X1113 51 g1113 5 b1113 NMOSWRAP
VG1114 g1114 0 1.8827482866649723
RB1114 b1114 0 10
X1114 51 g1114 5 b1114 NMOSWRAP
VG1115 g1115 0 1.5255999126489781
RB1115 b1115 0 10
X1115 51 g1115 6 b1115 NMOSWRAP
VG1116 g1116 0 2.0441248413645288
RB1116 b1116 0 10
X1116 51 g1116 6 b1116 NMOSWRAP
VG1117 g1117 0 1.0703201194323884
RB1117 b1117 0 10
X1117 51 g1117 6 b1117 NMOSWRAP
VG1118 g1118 0 2.8124628395745681
RB1118 b1118 0 10
X1118 51 g1118 7 b1118 NMOSWRAP
VG1119 g1119 0 2.6327286110397123
RB1119 b1119 0 10
X1119 51 g1119 7 b1119 NMOSWRAP
VG1120 g1120 0 2.1051626650210089
RB1120 b1120 0 10
X1120 51 g1120 7 b1120 NMOSWRAP
VG1121 g1121 0 2.7036171655144861
RB1121 b1121 0 10
X1121 51 g1121 8 b1121 NMOSWRAP
VG1122 g1122 0 2.9247901476216009
RB1122 b1122 0 10
X1122 51 g1122 8 b1122 NMOSWRAP
VG1123 g1123 0 1.2210445881053211
RB1123 b1123 0 10
X1123 51 g1123 8 b1123 NMOSWRAP
VG1124 g1124 0 2.2616636168196074
RB1124 b1124 0 10
X1124 51 g1124 9 b1124 NMOSWRAP
VG1125 g1125 0 2.9959880018713170
RB1125 b1125 0 10
X1125 51 g1125 9 b1125 NMOSWRAP
VG1126 g1126 0 2.9757783386670522
RB1126 b1126 0 10
X1126 51 g1126 9 b1126 NMOSWRAP
VG1127 g1127 0 2.2066459845814892
RB1127 b1127 0 10
X1127 51 g1127 10 b1127 NMOSWRAP
VG1128 g1128 0 1.2560417409016333
RB1128 b1128 0 10
X1128 51 g1128 10 b1128 NMOSWRAP
VG1129 g1129 0 2.1663856619810566
RB1129 b1129 0 10
X1129 51 g1129 10 b1129 NMOSWRAP
VG1130 g1130 0 1.0041292711488434
RB1130 b1130 0 10
X1130 51 g1130 11 b1130 NMOSWRAP
VG1131 g1131 0 1.3978226693337192
RB1131 b1131 0 10
X1131 51 g1131 12 b1131 NMOSWRAP
VG1132 g1132 0 2.9122463191199199
RB1132 b1132 0 10
X1132 51 g1132 12 b1132 NMOSWRAP
VG1133 g1133 0 1.6608811452056877
RB1133 b1133 0 10
X1133 51 g1133 12 b1133 NMOSWRAP
VG1134 g1134 0 2.2767802115538971
RB1134 b1134 0 10
X1134 52 g1134 3 b1134 NMOSWRAP
VG1135 g1135 0 1.5617189892644854
RB1135 b1135 0 10
X1135 52 g1135 3 b1135 NMOSWRAP
VG1136 g1136 0 2.8956437742231791
RB1136 b1136 0 10
X1136 52 g1136 3 b1136 NMOSWRAP
VG1137 g1137 0 2.4571174598989733
RB1137 b1137 0 10
X1137 52 g1137 4 b1137 NMOSWRAP
VG1138 g1138 0 1.6593023151628252
RB1138 b1138 0 10
X1138 52 g1138 4 b1138 NMOSWRAP
VG1139 g1139 0 2.5835228423607415
RB1139 b1139 0 10
X1139 52 g1139 4 b1139 NMOSWRAP
VG1140 g1140 0 1.2163310489526753
RB1140 b1140 0 10
X1140 52 g1140 5 b1140 NMOSWRAP
VG1141 g1141 0 1.7846378801309188
RB1141 b1141 0 10
X1141 52 g1141 5 b1141 NMOSWRAP
VG1142 g1142 0 1.4424362554631847
RB1142 b1142 0 10
X1142 52 g1142 5 b1142 NMOSWRAP
VG1143 g1143 0 2.3674528945520925
RB1143 b1143 0 10
X1143 52 g1143 6 b1143 NMOSWRAP
VG1144 g1144 0 1.2048925635438608
RB1144 b1144 0 10
X1144 52 g1144 6 b1144 NMOSWRAP
VG1145 g1145 0 1.7940516645653481
RB1145 b1145 0 10
X1145 52 g1145 6 b1145 NMOSWRAP
VG1146 g1146 0 1.5532994604183792
RB1146 b1146 0 10
X1146 52 g1146 7 b1146 NMOSWRAP
VG1147 g1147 0 2.0126858386476085
RB1147 b1147 0 10
X1147 52 g1147 7 b1147 NMOSWRAP
VG1148 g1148 0 1.6997953610077579
RB1148 b1148 0 10
X1148 52 g1148 7 b1148 NMOSWRAP
VG1149 g1149 0 2.4128211553340222
RB1149 b1149 0 10
X1149 52 g1149 8 b1149 NMOSWRAP
VG1150 g1150 0 1.0491540486139321
RB1150 b1150 0 10
X1150 52 g1150 8 b1150 NMOSWRAP
VG1151 g1151 0 2.2679738426118150
RB1151 b1151 0 10
X1151 52 g1151 8 b1151 NMOSWRAP
VG1152 g1152 0 1.4611425793876400
RB1152 b1152 0 10
X1152 52 g1152 9 b1152 NMOSWRAP
VG1153 g1153 0 1.5374180575136986
RB1153 b1153 0 10
X1153 52 g1153 9 b1153 NMOSWRAP
VG1154 g1154 0 2.6005112071670471
RB1154 b1154 0 10
X1154 52 g1154 9 b1154 NMOSWRAP
VG1155 g1155 0 2.9111367879608414
RB1155 b1155 0 10
X1155 52 g1155 10 b1155 NMOSWRAP
VG1156 g1156 0 1.6331004200541732
RB1156 b1156 0 10
X1156 52 g1156 10 b1156 NMOSWRAP
VG1157 g1157 0 2.6536105407381516
RB1157 b1157 0 10
X1157 52 g1157 10 b1157 NMOSWRAP
VG1158 g1158 0 1.2079816759424662
RB1158 b1158 0 10
X1158 52 g1158 11 b1158 NMOSWRAP
VG1159 g1159 0 2.2679633060147664
RB1159 b1159 0 10
X1159 52 g1159 11 b1159 NMOSWRAP
VG1160 g1160 0 2.5020645990698376
RB1160 b1160 0 10
X1160 52 g1160 11 b1160 NMOSWRAP
VG1161 g1161 0 1.3119558560689131
RB1161 b1161 0 10
X1161 52 g1161 12 b1161 NMOSWRAP
VG1162 g1162 0 1.8520047753391211
RB1162 b1162 0 10
X1162 52 g1162 12 b1162 NMOSWRAP
VG1163 g1163 0 2.7854143284979633
RB1163 b1163 0 10
X1163 52 g1163 12 b1163 NMOSWRAP
VG1164 g1164 0 1.2071569268967444
RB1164 b1164 0 10
X1164 53 g1164 3 b1164 NMOSWRAP
VG1165 g1165 0 1.0361927164029503
RB1165 b1165 0 10
X1165 53 g1165 3 b1165 NMOSWRAP
VG1166 g1166 0 2.1811707580958677
RB1166 b1166 0 10
X1166 53 g1166 3 b1166 NMOSWRAP
VG1167 g1167 0 1.8710630810618669
RB1167 b1167 0 10
X1167 53 g1167 4 b1167 NMOSWRAP
VG1168 g1168 0 2.5973784977678056
RB1168 b1168 0 10
X1168 53 g1168 4 b1168 NMOSWRAP
VG1169 g1169 0 2.8469110764082135
RB1169 b1169 0 10
X1169 53 g1169 4 b1169 NMOSWRAP
VG1170 g1170 0 1.5983072890876322
RB1170 b1170 0 10
X1170 53 g1170 5 b1170 NMOSWRAP
VG1171 g1171 0 1.7768082343382106
RB1171 b1171 0 10
X1171 53 g1171 5 b1171 NMOSWRAP
VG1172 g1172 0 1.9725441726586297
RB1172 b1172 0 10
X1172 53 g1172 5 b1172 NMOSWRAP
VG1173 g1173 0 2.1763029208705986
RB1173 b1173 0 10
X1173 53 g1173 6 b1173 NMOSWRAP
VG1174 g1174 0 2.9677076593632332
RB1174 b1174 0 10
X1174 53 g1174 6 b1174 NMOSWRAP
VG1175 g1175 0 2.3946605016601028
RB1175 b1175 0 10
X1175 53 g1175 6 b1175 NMOSWRAP
VG1176 g1176 0 1.7790970146911376
RB1176 b1176 0 10
X1176 53 g1176 7 b1176 NMOSWRAP
VG1177 g1177 0 1.5275353729009242
RB1177 b1177 0 10
X1177 53 g1177 7 b1177 NMOSWRAP
VG1178 g1178 0 2.8892514368442481
RB1178 b1178 0 10
X1178 53 g1178 7 b1178 NMOSWRAP
VG1179 g1179 0 1.2710968662170128
RB1179 b1179 0 10
X1179 53 g1179 8 b1179 NMOSWRAP
VG1180 g1180 0 2.4405317050095161
RB1180 b1180 0 10
X1180 53 g1180 8 b1180 NMOSWRAP
VG1181 g1181 0 2.8507900505848811
RB1181 b1181 0 10
X1181 53 g1181 8 b1181 NMOSWRAP
VG1182 g1182 0 2.3293311730688773
RB1182 b1182 0 10
X1182 53 g1182 9 b1182 NMOSWRAP
VG1183 g1183 0 1.8461088803322423
RB1183 b1183 0 10
X1183 53 g1183 9 b1183 NMOSWRAP
VG1184 g1184 0 1.3979818798509680
RB1184 b1184 0 10
X1184 53 g1184 9 b1184 NMOSWRAP
VG1185 g1185 0 1.7349506445038545
RB1185 b1185 0 10
X1185 53 g1185 10 b1185 NMOSWRAP
VG1186 g1186 0 2.4137436188402441
RB1186 b1186 0 10
X1186 53 g1186 10 b1186 NMOSWRAP
VG1187 g1187 0 2.2990684483505937
RB1187 b1187 0 10
X1187 53 g1187 10 b1187 NMOSWRAP
VG1188 g1188 0 2.8559523331967158
RB1188 b1188 0 10
X1188 53 g1188 11 b1188 NMOSWRAP
VG1189 g1189 0 2.7337218273187496
RB1189 b1189 0 10
X1189 53 g1189 11 b1189 NMOSWRAP
VG1190 g1190 0 2.6323015045327365
RB1190 b1190 0 10
X1190 53 g1190 11 b1190 NMOSWRAP
VG1191 g1191 0 2.8229017507015248
RB1191 b1191 0 10
X1191 53 g1191 12 b1191 NMOSWRAP
VG1192 g1192 0 1.5526743054740988
RB1192 b1192 0 10
X1192 53 g1192 12 b1192 NMOSWRAP
VG1193 g1193 0 1.7390470802792990
RB1193 b1193 0 10
X1193 53 g1193 12 b1193 NMOSWRAP
VG1194 g1194 0 1.7597878075720348
RB1194 b1194 0 10
X1194 54 g1194 3 b1194 NMOSWRAP
VG1195 g1195 0 2.1209011774195607
RB1195 b1195 0 10
X1195 54 g1195 3 b1195 NMOSWRAP
VG1196 g1196 0 2.3364364590855420
RB1196 b1196 0 10
X1196 54 g1196 3 b1196 NMOSWRAP
VG1197 g1197 0 1.5734333660807887
RB1197 b1197 0 10
X1197 54 g1197 4 b1197 NMOSWRAP
VG1198 g1198 0 1.0389249346186007
RB1198 b1198 0 10
X1198 54 g1198 4 b1198 NMOSWRAP
VG1199 g1199 0 1.7984447673158186
RB1199 b1199 0 10
X1199 54 g1199 5 b1199 NMOSWRAP
VG1200 g1200 0 1.6170559191088010
RB1200 b1200 0 10
X1200 54 g1200 5 b1200 NMOSWRAP
VG1201 g1201 0 2.8843694380360958
RB1201 b1201 0 10
X1201 54 g1201 5 b1201 NMOSWRAP
VG1202 g1202 0 2.7765300810880871
RB1202 b1202 0 10
X1202 54 g1202 6 b1202 NMOSWRAP
VG1203 g1203 0 2.7206213566868391
RB1203 b1203 0 10
X1203 54 g1203 6 b1203 NMOSWRAP
VG1204 g1204 0 2.3059995218904863
RB1204 b1204 0 10
X1204 54 g1204 6 b1204 NMOSWRAP
VG1205 g1205 0 1.6885783293978778
RB1205 b1205 0 10
X1205 54 g1205 7 b1205 NMOSWRAP
VG1206 g1206 0 2.0976985347986092
RB1206 b1206 0 10
X1206 54 g1206 7 b1206 NMOSWRAP
VG1207 g1207 0 2.6304500814327456
RB1207 b1207 0 10
X1207 54 g1207 7 b1207 NMOSWRAP
VG1208 g1208 0 1.1972207374456221
RB1208 b1208 0 10
X1208 54 g1208 8 b1208 NMOSWRAP
VG1209 g1209 0 2.6021497605106094
RB1209 b1209 0 10
X1209 54 g1209 8 b1209 NMOSWRAP
VG1210 g1210 0 1.0823595826562433
RB1210 b1210 0 10
X1210 54 g1210 8 b1210 NMOSWRAP
VG1211 g1211 0 2.6328420624287112
RB1211 b1211 0 10
X1211 54 g1211 9 b1211 NMOSWRAP
VG1212 g1212 0 2.6151276083197468
RB1212 b1212 0 10
X1212 54 g1212 9 b1212 NMOSWRAP
VG1213 g1213 0 1.1020146176575116
RB1213 b1213 0 10
X1213 54 g1213 9 b1213 NMOSWRAP
VG1214 g1214 0 2.2543214229237165
RB1214 b1214 0 10
X1214 54 g1214 10 b1214 NMOSWRAP
VG1215 g1215 0 2.0049061486257944
RB1215 b1215 0 10
X1215 54 g1215 10 b1215 NMOSWRAP
VG1216 g1216 0 1.3396390063434294
RB1216 b1216 0 10
X1216 54 g1216 10 b1216 NMOSWRAP
VG1217 g1217 0 1.2967578753547513
RB1217 b1217 0 10
X1217 54 g1217 11 b1217 NMOSWRAP
VG1218 g1218 0 2.5465182521340464
RB1218 b1218 0 10
X1218 54 g1218 11 b1218 NMOSWRAP
VG1219 g1219 0 2.1353854976736883
RB1219 b1219 0 10
X1219 54 g1219 11 b1219 NMOSWRAP
VG1220 g1220 0 2.9659982698330651
RB1220 b1220 0 10
X1220 54 g1220 12 b1220 NMOSWRAP
VG1221 g1221 0 2.9644955545766880
RB1221 b1221 0 10
X1221 54 g1221 12 b1221 NMOSWRAP
VG1222 g1222 0 2.9853339869285325
RB1222 b1222 0 10
X1222 54 g1222 12 b1222 NMOSWRAP
VG1223 g1223 0 1.2372310367315318
RB1223 b1223 0 10
X1223 55 g1223 3 b1223 NMOSWRAP
VG1224 g1224 0 2.8765122739279247
RB1224 b1224 0 10
X1224 55 g1224 3 b1224 NMOSWRAP
VG1225 g1225 0 1.4891392180411256
RB1225 b1225 0 10
X1225 55 g1225 3 b1225 NMOSWRAP
VG1226 g1226 0 1.9164245195172240
RB1226 b1226 0 10
X1226 55 g1226 4 b1226 NMOSWRAP
VG1227 g1227 0 2.5148131116434520
RB1227 b1227 0 10
X1227 55 g1227 4 b1227 NMOSWRAP
VG1228 g1228 0 1.4072418641544640
RB1228 b1228 0 10
X1228 55 g1228 4 b1228 NMOSWRAP
VG1229 g1229 0 2.1326232111086600
RB1229 b1229 0 10
X1229 55 g1229 5 b1229 NMOSWRAP
VG1230 g1230 0 1.3716334964519914
RB1230 b1230 0 10
X1230 55 g1230 5 b1230 NMOSWRAP
VG1231 g1231 0 1.2094722133625866
RB1231 b1231 0 10
X1231 55 g1231 5 b1231 NMOSWRAP
VG1232 g1232 0 1.2331172248591971
RB1232 b1232 0 10
X1232 55 g1232 6 b1232 NMOSWRAP
VG1233 g1233 0 1.7152780696964376
RB1233 b1233 0 10
X1233 55 g1233 6 b1233 NMOSWRAP
VG1234 g1234 0 1.0093096736743670
RB1234 b1234 0 10
X1234 55 g1234 6 b1234 NMOSWRAP
VG1235 g1235 0 1.8497078424033790
RB1235 b1235 0 10
X1235 55 g1235 7 b1235 NMOSWRAP
VG1236 g1236 0 2.3283942101622981
RB1236 b1236 0 10
X1236 55 g1236 7 b1236 NMOSWRAP
VG1237 g1237 0 1.8033763700079775
RB1237 b1237 0 10
X1237 55 g1237 7 b1237 NMOSWRAP
VG1238 g1238 0 1.1715892010396702
RB1238 b1238 0 10
X1238 55 g1238 8 b1238 NMOSWRAP
VG1239 g1239 0 1.1253777240472811
RB1239 b1239 0 10
X1239 55 g1239 8 b1239 NMOSWRAP
VG1240 g1240 0 1.5562330255297234
RB1240 b1240 0 10
X1240 55 g1240 8 b1240 NMOSWRAP
VG1241 g1241 0 1.3386253810872015
RB1241 b1241 0 10
X1241 55 g1241 9 b1241 NMOSWRAP
VG1242 g1242 0 2.9301899464359389
RB1242 b1242 0 10
X1242 55 g1242 9 b1242 NMOSWRAP
VG1243 g1243 0 1.3024604499481700
RB1243 b1243 0 10
X1243 55 g1243 9 b1243 NMOSWRAP
VG1244 g1244 0 2.6109248748099931
RB1244 b1244 0 10
X1244 55 g1244 10 b1244 NMOSWRAP
VG1245 g1245 0 2.1722158834822896
RB1245 b1245 0 10
X1245 55 g1245 10 b1245 NMOSWRAP
VG1246 g1246 0 2.1385738399685890
RB1246 b1246 0 10
X1246 55 g1246 10 b1246 NMOSWRAP
VG1247 g1247 0 2.0241614318475691
RB1247 b1247 0 10
X1247 55 g1247 11 b1247 NMOSWRAP
VG1248 g1248 0 2.9435261522279021
RB1248 b1248 0 10
X1248 55 g1248 11 b1248 NMOSWRAP
VG1249 g1249 0 1.7276895501832756
RB1249 b1249 0 10
X1249 55 g1249 11 b1249 NMOSWRAP
VG1250 g1250 0 2.5758315019077527
RB1250 b1250 0 10
X1250 55 g1250 12 b1250 NMOSWRAP
VG1251 g1251 0 2.1105882149339195
RB1251 b1251 0 10
X1251 55 g1251 12 b1251 NMOSWRAP
VG1252 g1252 0 1.7912673352514523
RB1252 b1252 0 10
X1252 56 g1252 3 b1252 NMOSWRAP
VG1253 g1253 0 2.9109318666115618
RB1253 b1253 0 10
X1253 56 g1253 3 b1253 NMOSWRAP
VG1254 g1254 0 2.1966319387293742
RB1254 b1254 0 10
X1254 56 g1254 3 b1254 NMOSWRAP
VG1255 g1255 0 1.2378338842920271
RB1255 b1255 0 10
X1255 56 g1255 4 b1255 NMOSWRAP
VG1256 g1256 0 1.8350784019937132
RB1256 b1256 0 10
X1256 56 g1256 4 b1256 NMOSWRAP
VG1257 g1257 0 2.5631634553632150
RB1257 b1257 0 10
X1257 56 g1257 4 b1257 NMOSWRAP
VG1258 g1258 0 2.3874940464784276
RB1258 b1258 0 10
X1258 56 g1258 5 b1258 NMOSWRAP
VG1259 g1259 0 2.8326806596731484
RB1259 b1259 0 10
X1259 56 g1259 5 b1259 NMOSWRAP
VG1260 g1260 0 1.5187547682830405
RB1260 b1260 0 10
X1260 56 g1260 5 b1260 NMOSWRAP
VG1261 g1261 0 2.5163874327076474
RB1261 b1261 0 10
X1261 56 g1261 6 b1261 NMOSWRAP
VG1262 g1262 0 1.9197504147890418
RB1262 b1262 0 10
X1262 56 g1262 6 b1262 NMOSWRAP
VG1263 g1263 0 2.1472194939336307
RB1263 b1263 0 10
X1263 56 g1263 7 b1263 NMOSWRAP
VG1264 g1264 0 2.9100933620125660
RB1264 b1264 0 10
X1264 56 g1264 7 b1264 NMOSWRAP
VG1265 g1265 0 2.9585726399783550
RB1265 b1265 0 10
X1265 56 g1265 7 b1265 NMOSWRAP
VG1266 g1266 0 2.7231819278511269
RB1266 b1266 0 10
X1266 56 g1266 8 b1266 NMOSWRAP
VG1267 g1267 0 1.7181941754605925
RB1267 b1267 0 10
X1267 56 g1267 8 b1267 NMOSWRAP
VG1268 g1268 0 2.7754016714546399
RB1268 b1268 0 10
X1268 56 g1268 8 b1268 NMOSWRAP
VG1269 g1269 0 2.2772183552828258
RB1269 b1269 0 10
X1269 56 g1269 9 b1269 NMOSWRAP
VG1270 g1270 0 1.8599935609414262
RB1270 b1270 0 10
X1270 56 g1270 9 b1270 NMOSWRAP
VG1271 g1271 0 1.0714853650009675
RB1271 b1271 0 10
X1271 56 g1271 9 b1271 NMOSWRAP
VG1272 g1272 0 2.5402562483831641
RB1272 b1272 0 10
X1272 56 g1272 10 b1272 NMOSWRAP
VG1273 g1273 0 2.0042111614482261
RB1273 b1273 0 10
X1273 56 g1273 10 b1273 NMOSWRAP
VG1274 g1274 0 2.5723769989301215
RB1274 b1274 0 10
X1274 56 g1274 10 b1274 NMOSWRAP
VG1275 g1275 0 2.4960455986865400
RB1275 b1275 0 10
X1275 56 g1275 11 b1275 NMOSWRAP
VG1276 g1276 0 2.5871347360967039
RB1276 b1276 0 10
X1276 56 g1276 11 b1276 NMOSWRAP
VG1277 g1277 0 1.6013023173935337
RB1277 b1277 0 10
X1277 56 g1277 11 b1277 NMOSWRAP
VG1278 g1278 0 2.6015971981352619
RB1278 b1278 0 10
X1278 56 g1278 12 b1278 NMOSWRAP
VG1279 g1279 0 2.0976926569323346
RB1279 b1279 0 10
X1279 56 g1279 12 b1279 NMOSWRAP
VG1280 g1280 0 1.9466524008982864
RB1280 b1280 0 10
X1280 56 g1280 12 b1280 NMOSWRAP
VG1281 g1281 0 2.3502518276415136
RB1281 b1281 0 10
X1281 57 g1281 3 b1281 NMOSWRAP
VG1282 g1282 0 1.0427173658766966
RB1282 b1282 0 10
X1282 57 g1282 4 b1282 NMOSWRAP
VG1283 g1283 0 1.2046336317751885
RB1283 b1283 0 10
X1283 57 g1283 4 b1283 NMOSWRAP
VG1284 g1284 0 1.5843547303350440
RB1284 b1284 0 10
X1284 57 g1284 4 b1284 NMOSWRAP
VG1285 g1285 0 2.9659802199156795
RB1285 b1285 0 10
X1285 57 g1285 5 b1285 NMOSWRAP
VG1286 g1286 0 1.2794915577299100
RB1286 b1286 0 10
X1286 57 g1286 5 b1286 NMOSWRAP
VG1287 g1287 0 1.6611926015184206
RB1287 b1287 0 10
X1287 57 g1287 5 b1287 NMOSWRAP
VG1288 g1288 0 1.1021061293838472
RB1288 b1288 0 10
X1288 57 g1288 6 b1288 NMOSWRAP
VG1289 g1289 0 1.6625377605854526
RB1289 b1289 0 10
X1289 57 g1289 6 b1289 NMOSWRAP
VG1290 g1290 0 1.6406525730216632
RB1290 b1290 0 10
X1290 57 g1290 6 b1290 NMOSWRAP
VG1291 g1291 0 2.8936143418890445
RB1291 b1291 0 10
X1291 57 g1291 7 b1291 NMOSWRAP
VG1292 g1292 0 2.6903081739914407
RB1292 b1292 0 10
X1292 57 g1292 7 b1292 NMOSWRAP
VG1293 g1293 0 1.7655284384855430
RB1293 b1293 0 10
X1293 57 g1293 7 b1293 NMOSWRAP
VG1294 g1294 0 1.0495381160784973
RB1294 b1294 0 10
X1294 57 g1294 8 b1294 NMOSWRAP
VG1295 g1295 0 2.6620622279907566
RB1295 b1295 0 10
X1295 57 g1295 8 b1295 NMOSWRAP
VG1296 g1296 0 2.3210723542890803
RB1296 b1296 0 10
X1296 57 g1296 8 b1296 NMOSWRAP
VG1297 g1297 0 1.3047289673026194
RB1297 b1297 0 10
X1297 57 g1297 9 b1297 NMOSWRAP
VG1298 g1298 0 2.9921425420203747
RB1298 b1298 0 10
X1298 57 g1298 9 b1298 NMOSWRAP
VG1299 g1299 0 1.2004668748482461
RB1299 b1299 0 10
X1299 57 g1299 9 b1299 NMOSWRAP
VG1300 g1300 0 2.7342290831873255
RB1300 b1300 0 10
X1300 57 g1300 10 b1300 NMOSWRAP
VG1301 g1301 0 1.5885323282593780
RB1301 b1301 0 10
X1301 57 g1301 10 b1301 NMOSWRAP
VG1302 g1302 0 1.8707069326503141
RB1302 b1302 0 10
X1302 57 g1302 10 b1302 NMOSWRAP
VG1303 g1303 0 2.5909130535526295
RB1303 b1303 0 10
X1303 57 g1303 11 b1303 NMOSWRAP
VG1304 g1304 0 2.3550167119880205
RB1304 b1304 0 10
X1304 57 g1304 11 b1304 NMOSWRAP
VG1305 g1305 0 2.8757287488880783
RB1305 b1305 0 10
X1305 57 g1305 11 b1305 NMOSWRAP
VG1306 g1306 0 2.2422806509207662
RB1306 b1306 0 10
X1306 57 g1306 12 b1306 NMOSWRAP
VG1307 g1307 0 1.1956203229581055
RB1307 b1307 0 10
X1307 57 g1307 12 b1307 NMOSWRAP
VG1308 g1308 0 2.7687207264839007
RB1308 b1308 0 10
X1308 57 g1308 12 b1308 NMOSWRAP
VG1309 g1309 0 2.5383110499771822
RB1309 b1309 0 10
X1309 58 g1309 3 b1309 NMOSWRAP
VG1310 g1310 0 2.4237409017866440
RB1310 b1310 0 10
X1310 58 g1310 3 b1310 NMOSWRAP
VG1311 g1311 0 1.1074670947074707
RB1311 b1311 0 10
X1311 58 g1311 3 b1311 NMOSWRAP
VG1312 g1312 0 1.7924454893234880
RB1312 b1312 0 10
X1312 58 g1312 4 b1312 NMOSWRAP
VG1313 g1313 0 1.3348716389190785
RB1313 b1313 0 10
X1313 58 g1313 4 b1313 NMOSWRAP
VG1314 g1314 0 2.6438078168157380
RB1314 b1314 0 10
X1314 58 g1314 5 b1314 NMOSWRAP
VG1315 g1315 0 2.4010572456357258
RB1315 b1315 0 10
X1315 58 g1315 5 b1315 NMOSWRAP
VG1316 g1316 0 2.7661551946382703
RB1316 b1316 0 10
X1316 58 g1316 6 b1316 NMOSWRAP
VG1317 g1317 0 2.9331502138483279
RB1317 b1317 0 10
X1317 58 g1317 6 b1317 NMOSWRAP
VG1318 g1318 0 2.5494952283849974
RB1318 b1318 0 10
X1318 58 g1318 6 b1318 NMOSWRAP
VG1319 g1319 0 2.9884661664415244
RB1319 b1319 0 10
X1319 58 g1319 7 b1319 NMOSWRAP
VG1320 g1320 0 2.2295397722885975
RB1320 b1320 0 10
X1320 58 g1320 7 b1320 NMOSWRAP
VG1321 g1321 0 1.0742592077828956
RB1321 b1321 0 10
X1321 58 g1321 7 b1321 NMOSWRAP
VG1322 g1322 0 1.0285030303005918
RB1322 b1322 0 10
X1322 58 g1322 8 b1322 NMOSWRAP
VG1323 g1323 0 1.6842077504075774
RB1323 b1323 0 10
X1323 58 g1323 8 b1323 NMOSWRAP
VG1324 g1324 0 2.6469434381350743
RB1324 b1324 0 10
X1324 58 g1324 8 b1324 NMOSWRAP
VG1325 g1325 0 2.7322694126494618
RB1325 b1325 0 10
X1325 58 g1325 9 b1325 NMOSWRAP
VG1326 g1326 0 2.9216250576453557
RB1326 b1326 0 10
X1326 58 g1326 9 b1326 NMOSWRAP
VG1327 g1327 0 1.1302429370976368
RB1327 b1327 0 10
X1327 58 g1327 9 b1327 NMOSWRAP
VG1328 g1328 0 1.0891422219753282
RB1328 b1328 0 10
X1328 58 g1328 10 b1328 NMOSWRAP
VG1329 g1329 0 2.8265671927340676
RB1329 b1329 0 10
X1329 58 g1329 10 b1329 NMOSWRAP
VG1330 g1330 0 1.6100933967257232
RB1330 b1330 0 10
X1330 58 g1330 11 b1330 NMOSWRAP
VG1331 g1331 0 2.1159748012192656
RB1331 b1331 0 10
X1331 58 g1331 11 b1331 NMOSWRAP
VG1332 g1332 0 2.9648897660014200
RB1332 b1332 0 10
X1332 58 g1332 11 b1332 NMOSWRAP
VG1333 g1333 0 1.8008970694718467
RB1333 b1333 0 10
X1333 58 g1333 12 b1333 NMOSWRAP
VG1334 g1334 0 2.3317427966196798
RB1334 b1334 0 10
X1334 58 g1334 12 b1334 NMOSWRAP
VG1335 g1335 0 1.8017591272639706
RB1335 b1335 0 10
X1335 58 g1335 12 b1335 NMOSWRAP
VG1336 g1336 0 2.5363893289255595
RB1336 b1336 0 10
X1336 59 g1336 3 b1336 NMOSWRAP
VG1337 g1337 0 2.0554294511457316
RB1337 b1337 0 10
X1337 59 g1337 3 b1337 NMOSWRAP
VG1338 g1338 0 1.4750462759726994
RB1338 b1338 0 10
X1338 59 g1338 3 b1338 NMOSWRAP
VG1339 g1339 0 1.5426122025169324
RB1339 b1339 0 10
X1339 59 g1339 4 b1339 NMOSWRAP
VG1340 g1340 0 1.5161184250768145
RB1340 b1340 0 10
X1340 59 g1340 4 b1340 NMOSWRAP
VG1341 g1341 0 2.0646406565171214
RB1341 b1341 0 10
X1341 59 g1341 4 b1341 NMOSWRAP
VG1342 g1342 0 2.4063780320313288
RB1342 b1342 0 10
X1342 59 g1342 5 b1342 NMOSWRAP
VG1343 g1343 0 2.8985598000862840
RB1343 b1343 0 10
X1343 59 g1343 5 b1343 NMOSWRAP
VG1344 g1344 0 2.3881747501659598
RB1344 b1344 0 10
X1344 59 g1344 6 b1344 NMOSWRAP
VG1345 g1345 0 2.5623856879247811
RB1345 b1345 0 10
X1345 59 g1345 6 b1345 NMOSWRAP
VG1346 g1346 0 1.3378522317291313
RB1346 b1346 0 10
X1346 59 g1346 6 b1346 NMOSWRAP
VG1347 g1347 0 1.7481252500146514
RB1347 b1347 0 10
X1347 59 g1347 7 b1347 NMOSWRAP
VG1348 g1348 0 1.8275604397165321
RB1348 b1348 0 10
X1348 59 g1348 7 b1348 NMOSWRAP
VG1349 g1349 0 2.3727604600009462
RB1349 b1349 0 10
X1349 59 g1349 7 b1349 NMOSWRAP
VG1350 g1350 0 1.5917839527537472
RB1350 b1350 0 10
X1350 59 g1350 8 b1350 NMOSWRAP
VG1351 g1351 0 1.6065838428393322
RB1351 b1351 0 10
X1351 59 g1351 8 b1351 NMOSWRAP
VG1352 g1352 0 1.7117783092817362
RB1352 b1352 0 10
X1352 59 g1352 8 b1352 NMOSWRAP
VG1353 g1353 0 2.6206041630864645
RB1353 b1353 0 10
X1353 59 g1353 9 b1353 NMOSWRAP
VG1354 g1354 0 2.1551801800866972
RB1354 b1354 0 10
X1354 59 g1354 9 b1354 NMOSWRAP
VG1355 g1355 0 1.1505545596654689
RB1355 b1355 0 10
X1355 59 g1355 9 b1355 NMOSWRAP
VG1356 g1356 0 1.1564921993809376
RB1356 b1356 0 10
X1356 59 g1356 10 b1356 NMOSWRAP
VG1357 g1357 0 1.7425738885649986
RB1357 b1357 0 10
X1357 59 g1357 10 b1357 NMOSWRAP
VG1358 g1358 0 2.5331821012123168
RB1358 b1358 0 10
X1358 59 g1358 10 b1358 NMOSWRAP
VG1359 g1359 0 2.3773668529573611
RB1359 b1359 0 10
X1359 59 g1359 11 b1359 NMOSWRAP
VG1360 g1360 0 2.4159647093023731
RB1360 b1360 0 10
X1360 59 g1360 11 b1360 NMOSWRAP
VG1361 g1361 0 2.5344201321081936
RB1361 b1361 0 10
X1361 59 g1361 12 b1361 NMOSWRAP
VG1362 g1362 0 1.5743054257726588
RB1362 b1362 0 10
X1362 59 g1362 12 b1362 NMOSWRAP
VG1363 g1363 0 2.0965125638841760
RB1363 b1363 0 10
X1363 59 g1363 12 b1363 NMOSWRAP
VG1364 g1364 0 2.0867052806335389
RB1364 b1364 0 10
X1364 60 g1364 3 b1364 NMOSWRAP
VG1365 g1365 0 2.4792650023598988
RB1365 b1365 0 10
X1365 60 g1365 3 b1365 NMOSWRAP
VG1366 g1366 0 2.9137411382112930
RB1366 b1366 0 10
X1366 60 g1366 3 b1366 NMOSWRAP
VG1367 g1367 0 1.5559798895909318
RB1367 b1367 0 10
X1367 60 g1367 4 b1367 NMOSWRAP
VG1368 g1368 0 2.5865633455140964
RB1368 b1368 0 10
X1368 60 g1368 4 b1368 NMOSWRAP
VG1369 g1369 0 2.3199410970465246
RB1369 b1369 0 10
X1369 60 g1369 4 b1369 NMOSWRAP
VG1370 g1370 0 2.1604757417269203
RB1370 b1370 0 10
X1370 60 g1370 5 b1370 NMOSWRAP
VG1371 g1371 0 2.5497595586948041
RB1371 b1371 0 10
X1371 60 g1371 5 b1371 NMOSWRAP
VG1372 g1372 0 2.8880649328561985
RB1372 b1372 0 10
X1372 60 g1372 5 b1372 NMOSWRAP
VG1373 g1373 0 1.0733828357388260
RB1373 b1373 0 10
X1373 60 g1373 6 b1373 NMOSWRAP
VG1374 g1374 0 1.2948002050264413
RB1374 b1374 0 10
X1374 60 g1374 6 b1374 NMOSWRAP
VG1375 g1375 0 2.5125744630022315
RB1375 b1375 0 10
X1375 60 g1375 6 b1375 NMOSWRAP
VG1376 g1376 0 1.1675827058201691
RB1376 b1376 0 10
X1376 60 g1376 7 b1376 NMOSWRAP
VG1377 g1377 0 2.0322474014821861
RB1377 b1377 0 10
X1377 60 g1377 7 b1377 NMOSWRAP
VG1378 g1378 0 1.4397215532832139
RB1378 b1378 0 10
X1378 60 g1378 7 b1378 NMOSWRAP
VG1379 g1379 0 1.5485914076855030
RB1379 b1379 0 10
X1379 60 g1379 8 b1379 NMOSWRAP
VG1380 g1380 0 2.4036809658888325
RB1380 b1380 0 10
X1380 60 g1380 8 b1380 NMOSWRAP
VG1381 g1381 0 1.0603855465374232
RB1381 b1381 0 10
X1381 60 g1381 8 b1381 NMOSWRAP
VG1382 g1382 0 2.7466388558038073
RB1382 b1382 0 10
X1382 60 g1382 9 b1382 NMOSWRAP
VG1383 g1383 0 1.8889579107045400
RB1383 b1383 0 10
X1383 60 g1383 9 b1383 NMOSWRAP
VG1384 g1384 0 2.0047865878142019
RB1384 b1384 0 10
X1384 60 g1384 9 b1384 NMOSWRAP
VG1385 g1385 0 2.0800959273873838
RB1385 b1385 0 10
X1385 60 g1385 10 b1385 NMOSWRAP
VG1386 g1386 0 2.2910885891589876
RB1386 b1386 0 10
X1386 60 g1386 10 b1386 NMOSWRAP
VG1387 g1387 0 1.6897131732454962
RB1387 b1387 0 10
X1387 60 g1387 10 b1387 NMOSWRAP
VG1388 g1388 0 1.2022149811269827
RB1388 b1388 0 10
X1388 60 g1388 11 b1388 NMOSWRAP
VG1389 g1389 0 1.6367578733323531
RB1389 b1389 0 10
X1389 60 g1389 11 b1389 NMOSWRAP
VG1390 g1390 0 1.3362842360456406
RB1390 b1390 0 10
X1390 60 g1390 11 b1390 NMOSWRAP
VG1391 g1391 0 2.1122663589009480
RB1391 b1391 0 10
X1391 60 g1391 12 b1391 NMOSWRAP
VG1392 g1392 0 1.6360572619207729
RB1392 b1392 0 10
X1392 60 g1392 12 b1392 NMOSWRAP
VG1393 g1393 0 2.9161343559868698
RB1393 b1393 0 10
X1393 60 g1393 12 b1393 NMOSWRAP
VG1394 g1394 0 2.9314685559605613
RB1394 b1394 0 10
X1394 61 g1394 3 b1394 NMOSWRAP
VG1395 g1395 0 2.2402517611364829
RB1395 b1395 0 10
X1395 61 g1395 3 b1395 NMOSWRAP
VG1396 g1396 0 2.2349945353345717
RB1396 b1396 0 10
X1396 61 g1396 3 b1396 NMOSWRAP
VG1397 g1397 0 2.9707571291342116
RB1397 b1397 0 10
X1397 61 g1397 4 b1397 NMOSWRAP
VG1398 g1398 0 2.7745663024703719
RB1398 b1398 0 10
X1398 61 g1398 4 b1398 NMOSWRAP
VG1399 g1399 0 2.5301398983162802
RB1399 b1399 0 10
X1399 61 g1399 4 b1399 NMOSWRAP
VG1400 g1400 0 1.6271812234854024
RB1400 b1400 0 10
X1400 61 g1400 5 b1400 NMOSWRAP
VG1401 g1401 0 1.7310780562361527
RB1401 b1401 0 10
X1401 61 g1401 5 b1401 NMOSWRAP
VG1402 g1402 0 1.4025335315217309
RB1402 b1402 0 10
X1402 61 g1402 5 b1402 NMOSWRAP
VG1403 g1403 0 1.9742962538347493
RB1403 b1403 0 10
X1403 61 g1403 6 b1403 NMOSWRAP
VG1404 g1404 0 2.9807370442791594
RB1404 b1404 0 10
X1404 61 g1404 6 b1404 NMOSWRAP
VG1405 g1405 0 2.8243019060231775
RB1405 b1405 0 10
X1405 61 g1405 6 b1405 NMOSWRAP
VG1406 g1406 0 1.2366988680389381
RB1406 b1406 0 10
X1406 61 g1406 7 b1406 NMOSWRAP
VG1407 g1407 0 1.0503805785810123
RB1407 b1407 0 10
X1407 61 g1407 7 b1407 NMOSWRAP
VG1408 g1408 0 2.7972753368165324
RB1408 b1408 0 10
X1408 61 g1408 7 b1408 NMOSWRAP
VG1409 g1409 0 2.0743402558974147
RB1409 b1409 0 10
X1409 61 g1409 8 b1409 NMOSWRAP
VG1410 g1410 0 1.4003797764169124
RB1410 b1410 0 10
X1410 61 g1410 8 b1410 NMOSWRAP
VG1411 g1411 0 2.3473065391692707
RB1411 b1411 0 10
X1411 61 g1411 8 b1411 NMOSWRAP
VG1412 g1412 0 2.2884463558596400
RB1412 b1412 0 10
X1412 61 g1412 9 b1412 NMOSWRAP
VG1413 g1413 0 1.2441712136729344
RB1413 b1413 0 10
X1413 61 g1413 9 b1413 NMOSWRAP
VG1414 g1414 0 1.5192004669952390
RB1414 b1414 0 10
X1414 61 g1414 9 b1414 NMOSWRAP
VG1415 g1415 0 1.1201559286265159
RB1415 b1415 0 10
X1415 61 g1415 10 b1415 NMOSWRAP
VG1416 g1416 0 1.4197209477402839
RB1416 b1416 0 10
X1416 61 g1416 10 b1416 NMOSWRAP
VG1417 g1417 0 1.2646113497061258
RB1417 b1417 0 10
X1417 61 g1417 10 b1417 NMOSWRAP
VG1418 g1418 0 1.3864725849491122
RB1418 b1418 0 10
X1418 61 g1418 11 b1418 NMOSWRAP
VG1419 g1419 0 2.3709342918262339
RB1419 b1419 0 10
X1419 61 g1419 11 b1419 NMOSWRAP
VG1420 g1420 0 1.0989994885221355
RB1420 b1420 0 10
X1420 61 g1420 11 b1420 NMOSWRAP
VG1421 g1421 0 1.2037092304964330
RB1421 b1421 0 10
X1421 61 g1421 12 b1421 NMOSWRAP
VG1422 g1422 0 1.2683472761565753
RB1422 b1422 0 10
X1422 61 g1422 12 b1422 NMOSWRAP
VG1423 g1423 0 1.6330822419162681
RB1423 b1423 0 10
X1423 61 g1423 12 b1423 NMOSWRAP
VG1424 g1424 0 1.5975006217038819
RB1424 b1424 0 10
X1424 62 g1424 3 b1424 NMOSWRAP
VG1425 g1425 0 1.5101275706332788
RB1425 b1425 0 10
X1425 62 g1425 3 b1425 NMOSWRAP
VG1426 g1426 0 2.5010733068648325
RB1426 b1426 0 10
X1426 62 g1426 3 b1426 NMOSWRAP
VG1427 g1427 0 2.9960455755162014
RB1427 b1427 0 10
X1427 62 g1427 4 b1427 NMOSWRAP
VG1428 g1428 0 2.0679558472575916
RB1428 b1428 0 10
X1428 62 g1428 4 b1428 NMOSWRAP
VG1429 g1429 0 2.8884054358278841
RB1429 b1429 0 10
X1429 62 g1429 4 b1429 NMOSWRAP
VG1430 g1430 0 1.7932202242521293
RB1430 b1430 0 10
X1430 62 g1430 5 b1430 NMOSWRAP
VG1431 g1431 0 1.2133648936054269
RB1431 b1431 0 10
X1431 62 g1431 5 b1431 NMOSWRAP
VG1432 g1432 0 1.8175476589396746
RB1432 b1432 0 10
X1432 62 g1432 5 b1432 NMOSWRAP
VG1433 g1433 0 1.5922555468293866
RB1433 b1433 0 10
X1433 62 g1433 6 b1433 NMOSWRAP
VG1434 g1434 0 1.9868139245783563
RB1434 b1434 0 10
X1434 62 g1434 6 b1434 NMOSWRAP
VG1435 g1435 0 2.3140873538328464
RB1435 b1435 0 10
X1435 62 g1435 6 b1435 NMOSWRAP
VG1436 g1436 0 1.9221004383048164
RB1436 b1436 0 10
X1436 62 g1436 7 b1436 NMOSWRAP
VG1437 g1437 0 2.8703210241556514
RB1437 b1437 0 10
X1437 62 g1437 7 b1437 NMOSWRAP
VG1438 g1438 0 2.7695296445987596
RB1438 b1438 0 10
X1438 62 g1438 7 b1438 NMOSWRAP
VG1439 g1439 0 2.4039551903323941
RB1439 b1439 0 10
X1439 62 g1439 8 b1439 NMOSWRAP
VG1440 g1440 0 1.9793698247290983
RB1440 b1440 0 10
X1440 62 g1440 8 b1440 NMOSWRAP
VG1441 g1441 0 1.2633745636289138
RB1441 b1441 0 10
X1441 62 g1441 8 b1441 NMOSWRAP
VG1442 g1442 0 1.7940273335552668
RB1442 b1442 0 10
X1442 62 g1442 9 b1442 NMOSWRAP
VG1443 g1443 0 2.4088030788023476
RB1443 b1443 0 10
X1443 62 g1443 9 b1443 NMOSWRAP
VG1444 g1444 0 1.5697710411074624
RB1444 b1444 0 10
X1444 62 g1444 9 b1444 NMOSWRAP
VG1445 g1445 0 1.2079761550868409
RB1445 b1445 0 10
X1445 62 g1445 10 b1445 NMOSWRAP
VG1446 g1446 0 2.8157969150212563
RB1446 b1446 0 10
X1446 62 g1446 10 b1446 NMOSWRAP
VG1447 g1447 0 2.4181016196310892
RB1447 b1447 0 10
X1447 62 g1447 10 b1447 NMOSWRAP
VG1448 g1448 0 2.2305528532701944
RB1448 b1448 0 10
X1448 62 g1448 11 b1448 NMOSWRAP
VG1449 g1449 0 2.5849978112178329
RB1449 b1449 0 10
X1449 62 g1449 11 b1449 NMOSWRAP
VG1450 g1450 0 2.6712920751669511
RB1450 b1450 0 10
X1450 62 g1450 11 b1450 NMOSWRAP
VG1451 g1451 0 1.9669179963420467
RB1451 b1451 0 10
X1451 62 g1451 12 b1451 NMOSWRAP
VG1452 g1452 0 2.7623765028188800
RB1452 b1452 0 10
X1452 62 g1452 12 b1452 NMOSWRAP
VG1453 g1453 0 2.8328380214022109
RB1453 b1453 0 10
X1453 62 g1453 12 b1453 NMOSWRAP
VG1454 g1454 0 1.5431021908495628
RB1454 b1454 0 10
X1454 63 g1454 3 b1454 NMOSWRAP
VG1455 g1455 0 2.2150907195815885
RB1455 b1455 0 10
X1455 63 g1455 3 b1455 NMOSWRAP
VG1456 g1456 0 2.0531680576409386
RB1456 b1456 0 10
X1456 63 g1456 3 b1456 NMOSWRAP
VG1457 g1457 0 2.0758915583038049
RB1457 b1457 0 10
X1457 63 g1457 4 b1457 NMOSWRAP
VG1458 g1458 0 2.8753261879291241
RB1458 b1458 0 10
X1458 63 g1458 4 b1458 NMOSWRAP
VG1459 g1459 0 1.6103774053860580
RB1459 b1459 0 10
X1459 63 g1459 4 b1459 NMOSWRAP
VG1460 g1460 0 2.9668679564691525
RB1460 b1460 0 10
X1460 63 g1460 5 b1460 NMOSWRAP
VG1461 g1461 0 2.8042624296084639
RB1461 b1461 0 10
X1461 63 g1461 5 b1461 NMOSWRAP
VG1462 g1462 0 1.9174457772270053
RB1462 b1462 0 10
X1462 63 g1462 5 b1462 NMOSWRAP
VG1463 g1463 0 2.6349065272363323
RB1463 b1463 0 10
X1463 63 g1463 6 b1463 NMOSWRAP
VG1464 g1464 0 2.5380939886402811
RB1464 b1464 0 10
X1464 63 g1464 6 b1464 NMOSWRAP
VG1465 g1465 0 2.3557899392370425
RB1465 b1465 0 10
X1465 63 g1465 6 b1465 NMOSWRAP
VG1466 g1466 0 1.6396677787663085
RB1466 b1466 0 10
X1466 63 g1466 7 b1466 NMOSWRAP
VG1467 g1467 0 1.3929019836419079
RB1467 b1467 0 10
X1467 63 g1467 7 b1467 NMOSWRAP
VG1468 g1468 0 2.3430553935315164
RB1468 b1468 0 10
X1468 63 g1468 7 b1468 NMOSWRAP
VG1469 g1469 0 2.6859465928021686
RB1469 b1469 0 10
X1469 63 g1469 8 b1469 NMOSWRAP
VG1470 g1470 0 1.0325055773547394
RB1470 b1470 0 10
X1470 63 g1470 8 b1470 NMOSWRAP
VG1471 g1471 0 2.2856067506170241
RB1471 b1471 0 10
X1471 63 g1471 8 b1471 NMOSWRAP
VG1472 g1472 0 1.8857460492444249
RB1472 b1472 0 10
X1472 63 g1472 9 b1472 NMOSWRAP
VG1473 g1473 0 2.7961755102539669
RB1473 b1473 0 10
X1473 63 g1473 9 b1473 NMOSWRAP
VG1474 g1474 0 1.6429458617084105
RB1474 b1474 0 10
X1474 63 g1474 9 b1474 NMOSWRAP
VG1475 g1475 0 1.9483696245272435
RB1475 b1475 0 10
X1475 63 g1475 10 b1475 NMOSWRAP
VG1476 g1476 0 2.0295342080703724
RB1476 b1476 0 10
X1476 63 g1476 10 b1476 NMOSWRAP
VG1477 g1477 0 1.2808790427421060
RB1477 b1477 0 10
X1477 63 g1477 10 b1477 NMOSWRAP
VG1478 g1478 0 2.4257846053978129
RB1478 b1478 0 10
X1478 63 g1478 11 b1478 NMOSWRAP
VG1479 g1479 0 2.6609526902419192
RB1479 b1479 0 10
X1479 63 g1479 11 b1479 NMOSWRAP
VG1480 g1480 0 1.1158185537925205
RB1480 b1480 0 10
X1480 63 g1480 11 b1480 NMOSWRAP
VG1481 g1481 0 1.5827776410738055
RB1481 b1481 0 10
X1481 63 g1481 12 b1481 NMOSWRAP
VG1482 g1482 0 1.0760893630701158
RB1482 b1482 0 10
X1482 63 g1482 12 b1482 NMOSWRAP
VG1483 g1483 0 2.9130882093764847
RB1483 b1483 0 10
X1483 63 g1483 12 b1483 NMOSWRAP
VG1484 g1484 0 2.3343376414076471
RB1484 b1484 0 10
X1484 64 g1484 3 b1484 NMOSWRAP
VG1485 g1485 0 2.9284008389095630
RB1485 b1485 0 10
X1485 64 g1485 3 b1485 NMOSWRAP
VG1486 g1486 0 2.0629885566626154
RB1486 b1486 0 10
X1486 64 g1486 3 b1486 NMOSWRAP
VG1487 g1487 0 2.6041370477912276
RB1487 b1487 0 10
X1487 64 g1487 4 b1487 NMOSWRAP
VG1488 g1488 0 1.7488279677594800
RB1488 b1488 0 10
X1488 64 g1488 4 b1488 NMOSWRAP
VG1489 g1489 0 1.7076380651452818
RB1489 b1489 0 10
X1489 64 g1489 4 b1489 NMOSWRAP
VG1490 g1490 0 1.7565356342102654
RB1490 b1490 0 10
X1490 64 g1490 5 b1490 NMOSWRAP
VG1491 g1491 0 2.3157242674528566
RB1491 b1491 0 10
X1491 64 g1491 5 b1491 NMOSWRAP
VG1492 g1492 0 1.7189063020433044
RB1492 b1492 0 10
X1492 64 g1492 5 b1492 NMOSWRAP
VG1493 g1493 0 2.8007349032084514
RB1493 b1493 0 10
X1493 64 g1493 6 b1493 NMOSWRAP
VG1494 g1494 0 2.9665497301003105
RB1494 b1494 0 10
X1494 64 g1494 6 b1494 NMOSWRAP
VG1495 g1495 0 1.0608530306740118
RB1495 b1495 0 10
X1495 64 g1495 6 b1495 NMOSWRAP
VG1496 g1496 0 1.3872465808049930
RB1496 b1496 0 10
X1496 64 g1496 7 b1496 NMOSWRAP
VG1497 g1497 0 1.2244999851747720
RB1497 b1497 0 10
X1497 64 g1497 7 b1497 NMOSWRAP
VG1498 g1498 0 1.0847280941828865
RB1498 b1498 0 10
X1498 64 g1498 7 b1498 NMOSWRAP
VG1499 g1499 0 1.4554819866945730
RB1499 b1499 0 10
X1499 64 g1499 8 b1499 NMOSWRAP
VG1500 g1500 0 1.8935866407381623
RB1500 b1500 0 10
X1500 64 g1500 8 b1500 NMOSWRAP
VG1501 g1501 0 2.6739807305773677
RB1501 b1501 0 10
X1501 64 g1501 8 b1501 NMOSWRAP
VG1502 g1502 0 1.4436480610199922
RB1502 b1502 0 10
X1502 64 g1502 9 b1502 NMOSWRAP
VG1503 g1503 0 1.9878905113244025
RB1503 b1503 0 10
X1503 64 g1503 9 b1503 NMOSWRAP
VG1504 g1504 0 2.8592374788935091
RB1504 b1504 0 10
X1504 64 g1504 9 b1504 NMOSWRAP
VG1505 g1505 0 2.3344294135733499
RB1505 b1505 0 10
X1505 64 g1505 10 b1505 NMOSWRAP
VG1506 g1506 0 2.5961580395119950
RB1506 b1506 0 10
X1506 64 g1506 10 b1506 NMOSWRAP
VG1507 g1507 0 2.1019879403709725
RB1507 b1507 0 10
X1507 64 g1507 10 b1507 NMOSWRAP
VG1508 g1508 0 2.9609329176812600
RB1508 b1508 0 10
X1508 64 g1508 11 b1508 NMOSWRAP
VG1509 g1509 0 2.1773243093629482
RB1509 b1509 0 10
X1509 64 g1509 12 b1509 NMOSWRAP
VG1510 g1510 0 1.0910214279251831
RB1510 b1510 0 10
X1510 64 g1510 12 b1510 NMOSWRAP
VG1511 g1511 0 1.3959655998795897
RB1511 b1511 0 10
X1511 64 g1511 12 b1511 NMOSWRAP
VG1512 g1512 0 1.8095472579142959
RB1512 b1512 0 10
X1512 65 g1512 3 b1512 NMOSWRAP
VG1513 g1513 0 2.2025543451475524
RB1513 b1513 0 10
X1513 65 g1513 3 b1513 NMOSWRAP
VG1514 g1514 0 2.5438617348179200
RB1514 b1514 0 10
X1514 65 g1514 3 b1514 NMOSWRAP
VG1515 g1515 0 1.8261722518077725
RB1515 b1515 0 10
X1515 65 g1515 4 b1515 NMOSWRAP
VG1516 g1516 0 2.4201166100313776
RB1516 b1516 0 10
X1516 65 g1516 4 b1516 NMOSWRAP
VG1517 g1517 0 2.5797390062182499
RB1517 b1517 0 10
X1517 65 g1517 4 b1517 NMOSWRAP
VG1518 g1518 0 1.6345203944999656
RB1518 b1518 0 10
X1518 65 g1518 5 b1518 NMOSWRAP
VG1519 g1519 0 2.9585404800716368
RB1519 b1519 0 10
X1519 65 g1519 5 b1519 NMOSWRAP
VG1520 g1520 0 2.2993129904716714
RB1520 b1520 0 10
X1520 65 g1520 5 b1520 NMOSWRAP
VG1521 g1521 0 2.7619961215722624
RB1521 b1521 0 10
X1521 65 g1521 6 b1521 NMOSWRAP
VG1522 g1522 0 2.1118753776172134
RB1522 b1522 0 10
X1522 65 g1522 6 b1522 NMOSWRAP
VG1523 g1523 0 2.4832062143046474
RB1523 b1523 0 10
X1523 65 g1523 6 b1523 NMOSWRAP
VG1524 g1524 0 2.5410881232327309
RB1524 b1524 0 10
X1524 65 g1524 7 b1524 NMOSWRAP
VG1525 g1525 0 2.8164967584691580
RB1525 b1525 0 10
X1525 65 g1525 7 b1525 NMOSWRAP
VG1526 g1526 0 1.3006995137427406
RB1526 b1526 0 10
X1526 65 g1526 7 b1526 NMOSWRAP
VG1527 g1527 0 2.1165668483384970
RB1527 b1527 0 10
X1527 65 g1527 8 b1527 NMOSWRAP
VG1528 g1528 0 1.8567570262117126
RB1528 b1528 0 10
X1528 65 g1528 8 b1528 NMOSWRAP
VG1529 g1529 0 2.8463180423474803
RB1529 b1529 0 10
X1529 65 g1529 8 b1529 NMOSWRAP
VG1530 g1530 0 1.2101893884979984
RB1530 b1530 0 10
X1530 65 g1530 9 b1530 NMOSWRAP
VG1531 g1531 0 2.9651477773618256
RB1531 b1531 0 10
X1531 65 g1531 9 b1531 NMOSWRAP
VG1532 g1532 0 2.7509026481865924
RB1532 b1532 0 10
X1532 65 g1532 9 b1532 NMOSWRAP
VG1533 g1533 0 1.1476525631284971
RB1533 b1533 0 10
X1533 65 g1533 10 b1533 NMOSWRAP
VG1534 g1534 0 1.9819327710809489
RB1534 b1534 0 10
X1534 65 g1534 10 b1534 NMOSWRAP
VG1535 g1535 0 2.4351190004250518
RB1535 b1535 0 10
X1535 65 g1535 10 b1535 NMOSWRAP
VG1536 g1536 0 2.4763030913821131
RB1536 b1536 0 10
X1536 65 g1536 11 b1536 NMOSWRAP
VG1537 g1537 0 2.8129882504758417
RB1537 b1537 0 10
X1537 65 g1537 11 b1537 NMOSWRAP
VG1538 g1538 0 2.5997308711646219
RB1538 b1538 0 10
X1538 65 g1538 11 b1538 NMOSWRAP
VG1539 g1539 0 1.6218607606881790
RB1539 b1539 0 10
X1539 65 g1539 12 b1539 NMOSWRAP
VG1540 g1540 0 1.9968695717249048
RB1540 b1540 0 10
X1540 65 g1540 12 b1540 NMOSWRAP
VG1541 g1541 0 2.4035715258717083
RB1541 b1541 0 10
X1541 66 g1541 3 b1541 NMOSWRAP
VG1542 g1542 0 1.2768736827287028
RB1542 b1542 0 10
X1542 66 g1542 3 b1542 NMOSWRAP
VG1543 g1543 0 1.3879815952003947
RB1543 b1543 0 10
X1543 66 g1543 3 b1543 NMOSWRAP
VG1544 g1544 0 1.9620848962197452
RB1544 b1544 0 10
X1544 66 g1544 4 b1544 NMOSWRAP
VG1545 g1545 0 1.5964915974110254
RB1545 b1545 0 10
X1545 66 g1545 4 b1545 NMOSWRAP
VG1546 g1546 0 2.7251184995681896
RB1546 b1546 0 10
X1546 66 g1546 4 b1546 NMOSWRAP
VG1547 g1547 0 2.1725546430412361
RB1547 b1547 0 10
X1547 66 g1547 5 b1547 NMOSWRAP
VG1548 g1548 0 1.6973303954367354
RB1548 b1548 0 10
X1548 66 g1548 5 b1548 NMOSWRAP
VG1549 g1549 0 2.6976660512088202
RB1549 b1549 0 10
X1549 66 g1549 5 b1549 NMOSWRAP
VG1550 g1550 0 2.6097568971084777
RB1550 b1550 0 10
X1550 66 g1550 6 b1550 NMOSWRAP
VG1551 g1551 0 2.9967097541985392
RB1551 b1551 0 10
X1551 66 g1551 6 b1551 NMOSWRAP
VG1552 g1552 0 2.6946153766674694
RB1552 b1552 0 10
X1552 66 g1552 6 b1552 NMOSWRAP
VG1553 g1553 0 1.8289130696113594
RB1553 b1553 0 10
X1553 66 g1553 7 b1553 NMOSWRAP
VG1554 g1554 0 1.2549977635399769
RB1554 b1554 0 10
X1554 66 g1554 7 b1554 NMOSWRAP
VG1555 g1555 0 2.6812818164009560
RB1555 b1555 0 10
X1555 66 g1555 7 b1555 NMOSWRAP
VG1556 g1556 0 1.1195158359207880
RB1556 b1556 0 10
X1556 66 g1556 8 b1556 NMOSWRAP
VG1557 g1557 0 1.7005424146897083
RB1557 b1557 0 10
X1557 66 g1557 8 b1557 NMOSWRAP
VG1558 g1558 0 2.8394759615425476
RB1558 b1558 0 10
X1558 66 g1558 8 b1558 NMOSWRAP
VG1559 g1559 0 2.9215329468902014
RB1559 b1559 0 10
X1559 66 g1559 9 b1559 NMOSWRAP
VG1560 g1560 0 2.2811291870424366
RB1560 b1560 0 10
X1560 66 g1560 9 b1560 NMOSWRAP
VG1561 g1561 0 2.3772966339674273
RB1561 b1561 0 10
X1561 66 g1561 9 b1561 NMOSWRAP
VG1562 g1562 0 1.0849089774510450
RB1562 b1562 0 10
X1562 66 g1562 10 b1562 NMOSWRAP
VG1563 g1563 0 2.0289606821790960
RB1563 b1563 0 10
X1563 66 g1563 10 b1563 NMOSWRAP
VG1564 g1564 0 2.0937363576126824
RB1564 b1564 0 10
X1564 66 g1564 10 b1564 NMOSWRAP
VG1565 g1565 0 1.6802014922482222
RB1565 b1565 0 10
X1565 66 g1565 11 b1565 NMOSWRAP
VG1566 g1566 0 1.1371936695077687
RB1566 b1566 0 10
X1566 66 g1566 11 b1566 NMOSWRAP
VG1567 g1567 0 1.4578151994487880
RB1567 b1567 0 10
X1567 66 g1567 11 b1567 NMOSWRAP
VG1568 g1568 0 1.7159678737223927
RB1568 b1568 0 10
X1568 66 g1568 12 b1568 NMOSWRAP
VG1569 g1569 0 1.8702839730326593
RB1569 b1569 0 10
X1569 66 g1569 12 b1569 NMOSWRAP
VG1570 g1570 0 2.1818534510671386
RB1570 b1570 0 10
X1570 66 g1570 12 b1570 NMOSWRAP
VG1571 g1571 0 2.4447830373964727
RB1571 b1571 0 10
X1571 67 g1571 3 b1571 NMOSWRAP
VG1572 g1572 0 1.6352637465478923
RB1572 b1572 0 10
X1572 67 g1572 3 b1572 NMOSWRAP
VG1573 g1573 0 1.6579075198379662
RB1573 b1573 0 10
X1573 67 g1573 3 b1573 NMOSWRAP
VG1574 g1574 0 1.0393832854474074
RB1574 b1574 0 10
X1574 67 g1574 4 b1574 NMOSWRAP
VG1575 g1575 0 1.0817497201880366
RB1575 b1575 0 10
X1575 67 g1575 4 b1575 NMOSWRAP
VG1576 g1576 0 1.5156433886170728
RB1576 b1576 0 10
X1576 67 g1576 4 b1576 NMOSWRAP
VG1577 g1577 0 2.4804899953499131
RB1577 b1577 0 10
X1577 67 g1577 5 b1577 NMOSWRAP
VG1578 g1578 0 2.2566276607478244
RB1578 b1578 0 10
X1578 67 g1578 5 b1578 NMOSWRAP
VG1579 g1579 0 2.5395780413556697
RB1579 b1579 0 10
X1579 67 g1579 5 b1579 NMOSWRAP
VG1580 g1580 0 2.5378388724296435
RB1580 b1580 0 10
X1580 67 g1580 6 b1580 NMOSWRAP
VG1581 g1581 0 2.7131349353386023
RB1581 b1581 0 10
X1581 67 g1581 6 b1581 NMOSWRAP
VG1582 g1582 0 2.4406385319737671
RB1582 b1582 0 10
X1582 67 g1582 6 b1582 NMOSWRAP
VG1583 g1583 0 2.9580218380016454
RB1583 b1583 0 10
X1583 67 g1583 7 b1583 NMOSWRAP
VG1584 g1584 0 2.7976504386036347
RB1584 b1584 0 10
X1584 67 g1584 7 b1584 NMOSWRAP
VG1585 g1585 0 2.1734343324464684
RB1585 b1585 0 10
X1585 67 g1585 8 b1585 NMOSWRAP
VG1586 g1586 0 2.1763153409823435
RB1586 b1586 0 10
X1586 67 g1586 8 b1586 NMOSWRAP
VG1587 g1587 0 1.0685340807044590
RB1587 b1587 0 10
X1587 67 g1587 8 b1587 NMOSWRAP
VG1588 g1588 0 2.9970531554167086
RB1588 b1588 0 10
X1588 67 g1588 9 b1588 NMOSWRAP
VG1589 g1589 0 1.2631519947322836
RB1589 b1589 0 10
X1589 67 g1589 9 b1589 NMOSWRAP
VG1590 g1590 0 2.4806943932631840
RB1590 b1590 0 10
X1590 67 g1590 9 b1590 NMOSWRAP
VG1591 g1591 0 2.6420303902486175
RB1591 b1591 0 10
X1591 67 g1591 10 b1591 NMOSWRAP
VG1592 g1592 0 1.7461090586104064
RB1592 b1592 0 10
X1592 67 g1592 10 b1592 NMOSWRAP
VG1593 g1593 0 1.3937041093306275
RB1593 b1593 0 10
X1593 67 g1593 10 b1593 NMOSWRAP
VG1594 g1594 0 1.1975197735811101
RB1594 b1594 0 10
X1594 67 g1594 11 b1594 NMOSWRAP
VG1595 g1595 0 2.4972120116591556
RB1595 b1595 0 10
X1595 67 g1595 11 b1595 NMOSWRAP
VG1596 g1596 0 1.9053070584113914
RB1596 b1596 0 10
X1596 67 g1596 11 b1596 NMOSWRAP
VG1597 g1597 0 2.4274355180022713
RB1597 b1597 0 10
X1597 67 g1597 12 b1597 NMOSWRAP
VG1598 g1598 0 2.8308152977036012
RB1598 b1598 0 10
X1598 67 g1598 12 b1598 NMOSWRAP
VG1599 g1599 0 1.2931674723021134
RB1599 b1599 0 10
X1599 67 g1599 12 b1599 NMOSWRAP
VG1600 g1600 0 2.8383420014475993
RB1600 b1600 0 10
X1600 68 g1600 3 b1600 NMOSWRAP
VG1601 g1601 0 1.8232529190168734
RB1601 b1601 0 10
X1601 68 g1601 3 b1601 NMOSWRAP
VG1602 g1602 0 1.6105340197945781
RB1602 b1602 0 10
X1602 68 g1602 3 b1602 NMOSWRAP
VG1603 g1603 0 2.8861245212055584
RB1603 b1603 0 10
X1603 68 g1603 4 b1603 NMOSWRAP
VG1604 g1604 0 2.9813033852127990
RB1604 b1604 0 10
X1604 68 g1604 4 b1604 NMOSWRAP
VG1605 g1605 0 1.3977844355348963
RB1605 b1605 0 10
X1605 68 g1605 4 b1605 NMOSWRAP
VG1606 g1606 0 2.3136766939039664
RB1606 b1606 0 10
X1606 68 g1606 5 b1606 NMOSWRAP
VG1607 g1607 0 1.2129906275421207
RB1607 b1607 0 10
X1607 68 g1607 5 b1607 NMOSWRAP
VG1608 g1608 0 2.3018280077150113
RB1608 b1608 0 10
X1608 68 g1608 5 b1608 NMOSWRAP
VG1609 g1609 0 2.6546264555516994
RB1609 b1609 0 10
X1609 68 g1609 6 b1609 NMOSWRAP
VG1610 g1610 0 2.3689970930481352
RB1610 b1610 0 10
X1610 68 g1610 6 b1610 NMOSWRAP
VG1611 g1611 0 1.8346662841251915
RB1611 b1611 0 10
X1611 68 g1611 6 b1611 NMOSWRAP
VG1612 g1612 0 1.7661327191275391
RB1612 b1612 0 10
X1612 68 g1612 7 b1612 NMOSWRAP
VG1613 g1613 0 1.7862448304468341
RB1613 b1613 0 10
X1613 68 g1613 7 b1613 NMOSWRAP
VG1614 g1614 0 2.1794236359858461
RB1614 b1614 0 10
X1614 68 g1614 7 b1614 NMOSWRAP
VG1615 g1615 0 2.7631345401449909
RB1615 b1615 0 10
X1615 68 g1615 8 b1615 NMOSWRAP
VG1616 g1616 0 2.8581323145375359
RB1616 b1616 0 10
X1616 68 g1616 8 b1616 NMOSWRAP
VG1617 g1617 0 1.1070592404146362
RB1617 b1617 0 10
X1617 68 g1617 8 b1617 NMOSWRAP
VG1618 g1618 0 1.3632447892913766
RB1618 b1618 0 10
X1618 68 g1618 9 b1618 NMOSWRAP
VG1619 g1619 0 1.2244486316565770
RB1619 b1619 0 10
X1619 68 g1619 9 b1619 NMOSWRAP
VG1620 g1620 0 1.3866692815338280
RB1620 b1620 0 10
X1620 68 g1620 9 b1620 NMOSWRAP
VG1621 g1621 0 1.6932156212183436
RB1621 b1621 0 10
X1621 68 g1621 10 b1621 NMOSWRAP
VG1622 g1622 0 2.0130633652452476
RB1622 b1622 0 10
X1622 68 g1622 10 b1622 NMOSWRAP
VG1623 g1623 0 2.2589224540183044
RB1623 b1623 0 10
X1623 68 g1623 10 b1623 NMOSWRAP
VG1624 g1624 0 2.4642844382794031
RB1624 b1624 0 10
X1624 68 g1624 11 b1624 NMOSWRAP
VG1625 g1625 0 2.7802230827716139
RB1625 b1625 0 10
X1625 68 g1625 11 b1625 NMOSWRAP
VG1626 g1626 0 2.9781768744595816
RB1626 b1626 0 10
X1626 68 g1626 11 b1626 NMOSWRAP
VG1627 g1627 0 2.3257129571142396
RB1627 b1627 0 10
X1627 68 g1627 12 b1627 NMOSWRAP
VG1628 g1628 0 2.6907290373355259
RB1628 b1628 0 10
X1628 68 g1628 12 b1628 NMOSWRAP
VG1629 g1629 0 2.5560776938493976
RB1629 b1629 0 10
X1629 68 g1629 12 b1629 NMOSWRAP
VG1630 g1630 0 1.6150640784374239
RB1630 b1630 0 10
X1630 69 g1630 3 b1630 NMOSWRAP
VG1631 g1631 0 2.7513845404698460
RB1631 b1631 0 10
X1631 69 g1631 3 b1631 NMOSWRAP
VG1632 g1632 0 1.0855262758955977
RB1632 b1632 0 10
X1632 69 g1632 3 b1632 NMOSWRAP
VG1633 g1633 0 1.0007346875029157
RB1633 b1633 0 10
X1633 69 g1633 4 b1633 NMOSWRAP
VG1634 g1634 0 1.5474652587769284
RB1634 b1634 0 10
X1634 69 g1634 4 b1634 NMOSWRAP
VG1635 g1635 0 1.9241950592548998
RB1635 b1635 0 10
X1635 69 g1635 4 b1635 NMOSWRAP
VG1636 g1636 0 2.2767257900013549
RB1636 b1636 0 10
X1636 69 g1636 5 b1636 NMOSWRAP
VG1637 g1637 0 1.2035405330890896
RB1637 b1637 0 10
X1637 69 g1637 5 b1637 NMOSWRAP
VG1638 g1638 0 2.3460202676696800
RB1638 b1638 0 10
X1638 69 g1638 5 b1638 NMOSWRAP
VG1639 g1639 0 2.6036317341193893
RB1639 b1639 0 10
X1639 69 g1639 6 b1639 NMOSWRAP
VG1640 g1640 0 1.3706258391587336
RB1640 b1640 0 10
X1640 69 g1640 6 b1640 NMOSWRAP
VG1641 g1641 0 1.8302505096635877
RB1641 b1641 0 10
X1641 69 g1641 6 b1641 NMOSWRAP
VG1642 g1642 0 2.0399699799066195
RB1642 b1642 0 10
X1642 69 g1642 7 b1642 NMOSWRAP
VG1643 g1643 0 1.9036140361689613
RB1643 b1643 0 10
X1643 69 g1643 7 b1643 NMOSWRAP
VG1644 g1644 0 2.5996598617769413
RB1644 b1644 0 10
X1644 69 g1644 7 b1644 NMOSWRAP
VG1645 g1645 0 2.9210447962386619
RB1645 b1645 0 10
X1645 69 g1645 8 b1645 NMOSWRAP
VG1646 g1646 0 2.5979063280163599
RB1646 b1646 0 10
X1646 69 g1646 8 b1646 NMOSWRAP
VG1647 g1647 0 1.1559856357516491
RB1647 b1647 0 10
X1647 69 g1647 8 b1647 NMOSWRAP
VG1648 g1648 0 2.6098711443182543
RB1648 b1648 0 10
X1648 69 g1648 9 b1648 NMOSWRAP
VG1649 g1649 0 1.1331926644711023
RB1649 b1649 0 10
X1649 69 g1649 9 b1649 NMOSWRAP
VG1650 g1650 0 1.4719407704831400
RB1650 b1650 0 10
X1650 69 g1650 9 b1650 NMOSWRAP
VG1651 g1651 0 1.3061937936714456
RB1651 b1651 0 10
X1651 69 g1651 10 b1651 NMOSWRAP
VG1652 g1652 0 1.3950382136921708
RB1652 b1652 0 10
X1652 69 g1652 10 b1652 NMOSWRAP
VG1653 g1653 0 2.0566302541147010
RB1653 b1653 0 10
X1653 69 g1653 10 b1653 NMOSWRAP
VG1654 g1654 0 2.3433797152217073
RB1654 b1654 0 10
X1654 69 g1654 11 b1654 NMOSWRAP
VG1655 g1655 0 1.9406425646720820
RB1655 b1655 0 10
X1655 69 g1655 11 b1655 NMOSWRAP
VG1656 g1656 0 2.9193912780584874
RB1656 b1656 0 10
X1656 69 g1656 11 b1656 NMOSWRAP
VG1657 g1657 0 1.4805846400603333
RB1657 b1657 0 10
X1657 69 g1657 12 b1657 NMOSWRAP
VG1658 g1658 0 2.5262804605095859
RB1658 b1658 0 10
X1658 69 g1658 12 b1658 NMOSWRAP
VG1659 g1659 0 2.7403643570142968
RB1659 b1659 0 10
X1659 69 g1659 12 b1659 NMOSWRAP
VG1660 g1660 0 2.1241322215094383
RB1660 b1660 0 10
X1660 70 g1660 3 b1660 NMOSWRAP
VG1661 g1661 0 1.9124450039231062
RB1661 b1661 0 10
X1661 70 g1661 3 b1661 NMOSWRAP
VG1662 g1662 0 2.1923688935584873
RB1662 b1662 0 10
X1662 70 g1662 3 b1662 NMOSWRAP
VG1663 g1663 0 1.8576195403206859
RB1663 b1663 0 10
X1663 70 g1663 4 b1663 NMOSWRAP
VG1664 g1664 0 2.1103877646467391
RB1664 b1664 0 10
X1664 70 g1664 4 b1664 NMOSWRAP
VG1665 g1665 0 1.8338679042576032
RB1665 b1665 0 10
X1665 70 g1665 4 b1665 NMOSWRAP
VG1666 g1666 0 1.8009394205882681
RB1666 b1666 0 10
X1666 70 g1666 5 b1666 NMOSWRAP
VG1667 g1667 0 2.3906929362790597
RB1667 b1667 0 10
X1667 70 g1667 5 b1667 NMOSWRAP
VG1668 g1668 0 1.1857024261359359
RB1668 b1668 0 10
X1668 70 g1668 5 b1668 NMOSWRAP
VG1669 g1669 0 1.3330841454576416
RB1669 b1669 0 10
X1669 70 g1669 6 b1669 NMOSWRAP
VG1670 g1670 0 2.7023969434300081
RB1670 b1670 0 10
X1670 70 g1670 6 b1670 NMOSWRAP
VG1671 g1671 0 2.5421546936303763
RB1671 b1671 0 10
X1671 70 g1671 6 b1671 NMOSWRAP
VG1672 g1672 0 1.5629074545887875
RB1672 b1672 0 10
X1672 70 g1672 7 b1672 NMOSWRAP
VG1673 g1673 0 1.7545378653315205
RB1673 b1673 0 10
X1673 70 g1673 7 b1673 NMOSWRAP
VG1674 g1674 0 2.8520530132569610
RB1674 b1674 0 10
X1674 70 g1674 7 b1674 NMOSWRAP
VG1675 g1675 0 2.6361544503477226
RB1675 b1675 0 10
X1675 70 g1675 8 b1675 NMOSWRAP
VG1676 g1676 0 2.2286925999592615
RB1676 b1676 0 10
X1676 70 g1676 8 b1676 NMOSWRAP
VG1677 g1677 0 1.4429803576059155
RB1677 b1677 0 10
X1677 70 g1677 8 b1677 NMOSWRAP
VG1678 g1678 0 1.0885039426305392
RB1678 b1678 0 10
X1678 70 g1678 9 b1678 NMOSWRAP
VG1679 g1679 0 1.8625156936837963
RB1679 b1679 0 10
X1679 70 g1679 9 b1679 NMOSWRAP
VG1680 g1680 0 2.3452542785149237
RB1680 b1680 0 10
X1680 70 g1680 9 b1680 NMOSWRAP
VG1681 g1681 0 2.6569609810357031
RB1681 b1681 0 10
X1681 70 g1681 10 b1681 NMOSWRAP
VG1682 g1682 0 2.7053780114845387
RB1682 b1682 0 10
X1682 70 g1682 10 b1682 NMOSWRAP
VG1683 g1683 0 1.0655518025867268
RB1683 b1683 0 10
X1683 70 g1683 10 b1683 NMOSWRAP
VG1684 g1684 0 1.4883140676737587
RB1684 b1684 0 10
X1684 70 g1684 11 b1684 NMOSWRAP
VG1685 g1685 0 1.6781891769548061
RB1685 b1685 0 10
X1685 70 g1685 11 b1685 NMOSWRAP
VG1686 g1686 0 1.3774644219187717
RB1686 b1686 0 10
X1686 70 g1686 11 b1686 NMOSWRAP
VG1687 g1687 0 2.6059507567276756
RB1687 b1687 0 10
X1687 70 g1687 12 b1687 NMOSWRAP
VG1688 g1688 0 2.5349315261698848
RB1688 b1688 0 10
X1688 70 g1688 12 b1688 NMOSWRAP
VG1689 g1689 0 2.0336660807619413
RB1689 b1689 0 10
X1689 70 g1689 12 b1689 NMOSWRAP
VG1690 g1690 0 2.9658529559917111
RB1690 b1690 0 10
X1690 71 g1690 3 b1690 NMOSWRAP
VG1691 g1691 0 1.2881170821816845
RB1691 b1691 0 10
X1691 71 g1691 3 b1691 NMOSWRAP
VG1692 g1692 0 2.7993034066553379
RB1692 b1692 0 10
X1692 71 g1692 3 b1692 NMOSWRAP
VG1693 g1693 0 1.2329265083238323
RB1693 b1693 0 10
X1693 71 g1693 4 b1693 NMOSWRAP
VG1694 g1694 0 1.3263634110282414
RB1694 b1694 0 10
X1694 71 g1694 4 b1694 NMOSWRAP
VG1695 g1695 0 2.3924384005012378
RB1695 b1695 0 10
X1695 71 g1695 4 b1695 NMOSWRAP
VG1696 g1696 0 1.2191393840833786
RB1696 b1696 0 10
X1696 71 g1696 5 b1696 NMOSWRAP
VG1697 g1697 0 2.1316901908374217
RB1697 b1697 0 10
X1697 71 g1697 5 b1697 NMOSWRAP
VG1698 g1698 0 1.8404670729453072
RB1698 b1698 0 10
X1698 71 g1698 5 b1698 NMOSWRAP
VG1699 g1699 0 2.4569479310820297
RB1699 b1699 0 10
X1699 71 g1699 6 b1699 NMOSWRAP
VG1700 g1700 0 2.8013504776177305
RB1700 b1700 0 10
X1700 71 g1700 6 b1700 NMOSWRAP
VG1701 g1701 0 2.5397430293381107
RB1701 b1701 0 10
X1701 71 g1701 6 b1701 NMOSWRAP
VG1702 g1702 0 2.6993797528423764
RB1702 b1702 0 10
X1702 71 g1702 7 b1702 NMOSWRAP
VG1703 g1703 0 1.0658908970624648
RB1703 b1703 0 10
X1703 71 g1703 7 b1703 NMOSWRAP
VG1704 g1704 0 1.6203909964884062
RB1704 b1704 0 10
X1704 71 g1704 7 b1704 NMOSWRAP
VG1705 g1705 0 2.0308661733726647
RB1705 b1705 0 10
X1705 71 g1705 8 b1705 NMOSWRAP
VG1706 g1706 0 1.8319066292595589
RB1706 b1706 0 10
X1706 71 g1706 8 b1706 NMOSWRAP
VG1707 g1707 0 1.4625099059593769
RB1707 b1707 0 10
X1707 71 g1707 8 b1707 NMOSWRAP
VG1708 g1708 0 1.6157481959200466
RB1708 b1708 0 10
X1708 71 g1708 9 b1708 NMOSWRAP
VG1709 g1709 0 2.8908619407832115
RB1709 b1709 0 10
X1709 71 g1709 9 b1709 NMOSWRAP
VG1710 g1710 0 1.5883617597427031
RB1710 b1710 0 10
X1710 71 g1710 9 b1710 NMOSWRAP
VG1711 g1711 0 1.7078082203595715
RB1711 b1711 0 10
X1711 71 g1711 10 b1711 NMOSWRAP
VG1712 g1712 0 1.0074195475000374
RB1712 b1712 0 10
X1712 71 g1712 10 b1712 NMOSWRAP
VG1713 g1713 0 2.6901552545557488
RB1713 b1713 0 10
X1713 71 g1713 10 b1713 NMOSWRAP
VG1714 g1714 0 1.3096814068031533
RB1714 b1714 0 10
X1714 71 g1714 11 b1714 NMOSWRAP
VG1715 g1715 0 1.4082885510274521
RB1715 b1715 0 10
X1715 71 g1715 11 b1715 NMOSWRAP
VG1716 g1716 0 1.5105290341840512
RB1716 b1716 0 10
X1716 71 g1716 12 b1716 NMOSWRAP
VG1717 g1717 0 2.7692441136896853
RB1717 b1717 0 10
X1717 71 g1717 12 b1717 NMOSWRAP
VG1718 g1718 0 1.4129028224926294
RB1718 b1718 0 10
X1718 71 g1718 12 b1718 NMOSWRAP
VG1719 g1719 0 2.5950527217358799
RB1719 b1719 0 10
X1719 72 g1719 3 b1719 NMOSWRAP
VG1720 g1720 0 2.6160986806458091
RB1720 b1720 0 10
X1720 72 g1720 3 b1720 NMOSWRAP
VG1721 g1721 0 2.8540411375727919
RB1721 b1721 0 10
X1721 72 g1721 3 b1721 NMOSWRAP
VG1722 g1722 0 1.2311226272006279
RB1722 b1722 0 10
X1722 72 g1722 4 b1722 NMOSWRAP
VG1723 g1723 0 1.4345579446756627
RB1723 b1723 0 10
X1723 72 g1723 4 b1723 NMOSWRAP
VG1724 g1724 0 2.4857965841614424
RB1724 b1724 0 10
X1724 72 g1724 4 b1724 NMOSWRAP
VG1725 g1725 0 1.3920015085614781
RB1725 b1725 0 10
X1725 72 g1725 5 b1725 NMOSWRAP
VG1726 g1726 0 1.5726590937468981
RB1726 b1726 0 10
X1726 72 g1726 5 b1726 NMOSWRAP
VG1727 g1727 0 1.3334831602227253
RB1727 b1727 0 10
X1727 72 g1727 5 b1727 NMOSWRAP
VG1728 g1728 0 1.3453933723100986
RB1728 b1728 0 10
X1728 72 g1728 6 b1728 NMOSWRAP
VG1729 g1729 0 1.9631067092564114
RB1729 b1729 0 10
X1729 72 g1729 6 b1729 NMOSWRAP
VG1730 g1730 0 1.2193661242259171
RB1730 b1730 0 10
X1730 72 g1730 6 b1730 NMOSWRAP
VG1731 g1731 0 1.6433952369272444
RB1731 b1731 0 10
X1731 72 g1731 7 b1731 NMOSWRAP
VG1732 g1732 0 1.8531878191977580
RB1732 b1732 0 10
X1732 72 g1732 7 b1732 NMOSWRAP
VG1733 g1733 0 1.0490962330479552
RB1733 b1733 0 10
X1733 72 g1733 8 b1733 NMOSWRAP
VG1734 g1734 0 1.7766663329489052
RB1734 b1734 0 10
X1734 72 g1734 8 b1734 NMOSWRAP
VG1735 g1735 0 1.1882448721710339
RB1735 b1735 0 10
X1735 72 g1735 8 b1735 NMOSWRAP
VG1736 g1736 0 1.9871570622923533
RB1736 b1736 0 10
X1736 72 g1736 9 b1736 NMOSWRAP
VG1737 g1737 0 2.6514763771141929
RB1737 b1737 0 10
X1737 72 g1737 9 b1737 NMOSWRAP
VG1738 g1738 0 2.6368443243635742
RB1738 b1738 0 10
X1738 72 g1738 9 b1738 NMOSWRAP
VG1739 g1739 0 1.1608970310748010
RB1739 b1739 0 10
X1739 72 g1739 10 b1739 NMOSWRAP
VG1740 g1740 0 2.2024555153490404
RB1740 b1740 0 10
X1740 72 g1740 10 b1740 NMOSWRAP
VG1741 g1741 0 2.6691727639424729
RB1741 b1741 0 10
X1741 72 g1741 10 b1741 NMOSWRAP
VG1742 g1742 0 1.4759450858692706
RB1742 b1742 0 10
X1742 72 g1742 11 b1742 NMOSWRAP
VG1743 g1743 0 2.5238530228991980
RB1743 b1743 0 10
X1743 72 g1743 11 b1743 NMOSWRAP
VG1744 g1744 0 2.7815286929001868
RB1744 b1744 0 10
X1744 72 g1744 11 b1744 NMOSWRAP
VG1745 g1745 0 2.6122483028808885
RB1745 b1745 0 10
X1745 72 g1745 12 b1745 NMOSWRAP
VG1746 g1746 0 1.2146020630310090
RB1746 b1746 0 10
X1746 72 g1746 12 b1746 NMOSWRAP
VG1747 g1747 0 1.0181199990447698
RB1747 b1747 0 10
X1747 72 g1747 12 b1747 NMOSWRAP
VG1748 g1748 0 1.3834482198436913
RB1748 b1748 0 10
X1748 73 g1748 3 b1748 NMOSWRAP
VG1749 g1749 0 1.5409546818932465
RB1749 b1749 0 10
X1749 73 g1749 3 b1749 NMOSWRAP
VG1750 g1750 0 2.2323659812319190
RB1750 b1750 0 10
X1750 73 g1750 3 b1750 NMOSWRAP
VG1751 g1751 0 1.7685463504846368
RB1751 b1751 0 10
X1751 73 g1751 4 b1751 NMOSWRAP
VG1752 g1752 0 2.4068140613229470
RB1752 b1752 0 10
X1752 73 g1752 4 b1752 NMOSWRAP
VG1753 g1753 0 1.7061499210432172
RB1753 b1753 0 10
X1753 73 g1753 4 b1753 NMOSWRAP
VG1754 g1754 0 1.3088508493092006
RB1754 b1754 0 10
X1754 73 g1754 5 b1754 NMOSWRAP
VG1755 g1755 0 1.6253796869720702
RB1755 b1755 0 10
X1755 73 g1755 5 b1755 NMOSWRAP
VG1756 g1756 0 2.7686484527782698
RB1756 b1756 0 10
X1756 73 g1756 5 b1756 NMOSWRAP
VG1757 g1757 0 2.9170646884901297
RB1757 b1757 0 10
X1757 73 g1757 6 b1757 NMOSWRAP
VG1758 g1758 0 1.4150254681347370
RB1758 b1758 0 10
X1758 73 g1758 6 b1758 NMOSWRAP
VG1759 g1759 0 2.5769367740488827
RB1759 b1759 0 10
X1759 73 g1759 6 b1759 NMOSWRAP
VG1760 g1760 0 1.5466974730797414
RB1760 b1760 0 10
X1760 73 g1760 7 b1760 NMOSWRAP
VG1761 g1761 0 2.7742630868628151
RB1761 b1761 0 10
X1761 73 g1761 7 b1761 NMOSWRAP
VG1762 g1762 0 1.3310912255925109
RB1762 b1762 0 10
X1762 73 g1762 7 b1762 NMOSWRAP
VG1763 g1763 0 2.3319198373881136
RB1763 b1763 0 10
X1763 73 g1763 8 b1763 NMOSWRAP
VG1764 g1764 0 1.1684225294263650
RB1764 b1764 0 10
X1764 73 g1764 8 b1764 NMOSWRAP
VG1765 g1765 0 2.9477866479477388
RB1765 b1765 0 10
X1765 73 g1765 8 b1765 NMOSWRAP
VG1766 g1766 0 2.4012666892810857
RB1766 b1766 0 10
X1766 73 g1766 9 b1766 NMOSWRAP
VG1767 g1767 0 2.6836314788101703
RB1767 b1767 0 10
X1767 73 g1767 9 b1767 NMOSWRAP
VG1768 g1768 0 2.1333386787260693
RB1768 b1768 0 10
X1768 73 g1768 9 b1768 NMOSWRAP
VG1769 g1769 0 1.9536027278577204
RB1769 b1769 0 10
X1769 73 g1769 10 b1769 NMOSWRAP
VG1770 g1770 0 2.2437647827887304
RB1770 b1770 0 10
X1770 73 g1770 11 b1770 NMOSWRAP
VG1771 g1771 0 2.0574830233988961
RB1771 b1771 0 10
X1771 73 g1771 11 b1771 NMOSWRAP
VG1772 g1772 0 1.9387687102903060
RB1772 b1772 0 10
X1772 73 g1772 11 b1772 NMOSWRAP
VG1773 g1773 0 2.5189005029152858
RB1773 b1773 0 10
X1773 73 g1773 12 b1773 NMOSWRAP
VG1774 g1774 0 1.3564019098785363
RB1774 b1774 0 10
X1774 73 g1774 12 b1774 NMOSWRAP
VG1775 g1775 0 1.3423440963103170
RB1775 b1775 0 10
X1775 73 g1775 12 b1775 NMOSWRAP
VG1776 g1776 0 1.8636853012994123
RB1776 b1776 0 10
X1776 74 g1776 3 b1776 NMOSWRAP
VG1777 g1777 0 1.6414958320898920
RB1777 b1777 0 10
X1777 74 g1777 3 b1777 NMOSWRAP
VG1778 g1778 0 1.1482490358260482
RB1778 b1778 0 10
X1778 74 g1778 3 b1778 NMOSWRAP
VG1779 g1779 0 2.6889409848374690
RB1779 b1779 0 10
X1779 74 g1779 4 b1779 NMOSWRAP
VG1780 g1780 0 2.5432056133886993
RB1780 b1780 0 10
X1780 74 g1780 4 b1780 NMOSWRAP
VG1781 g1781 0 2.0878429996059698
RB1781 b1781 0 10
X1781 74 g1781 4 b1781 NMOSWRAP
VG1782 g1782 0 2.9586490745287382
RB1782 b1782 0 10
X1782 74 g1782 5 b1782 NMOSWRAP
VG1783 g1783 0 1.1452001330952106
RB1783 b1783 0 10
X1783 74 g1783 5 b1783 NMOSWRAP
VG1784 g1784 0 2.5333386020557498
RB1784 b1784 0 10
X1784 74 g1784 5 b1784 NMOSWRAP
VG1785 g1785 0 1.5327407832181936
RB1785 b1785 0 10
X1785 74 g1785 6 b1785 NMOSWRAP
VG1786 g1786 0 1.7371978398871508
RB1786 b1786 0 10
X1786 74 g1786 6 b1786 NMOSWRAP
VG1787 g1787 0 1.4385587704061351
RB1787 b1787 0 10
X1787 74 g1787 6 b1787 NMOSWRAP
VG1788 g1788 0 2.5780757829237304
RB1788 b1788 0 10
X1788 74 g1788 7 b1788 NMOSWRAP
VG1789 g1789 0 1.2884802040431320
RB1789 b1789 0 10
X1789 74 g1789 7 b1789 NMOSWRAP
VG1790 g1790 0 2.6800333954705557
RB1790 b1790 0 10
X1790 74 g1790 7 b1790 NMOSWRAP
VG1791 g1791 0 2.3231552964596678
RB1791 b1791 0 10
X1791 74 g1791 8 b1791 NMOSWRAP
VG1792 g1792 0 1.1180464905382295
RB1792 b1792 0 10
X1792 74 g1792 8 b1792 NMOSWRAP
VG1793 g1793 0 2.6219634632003066
RB1793 b1793 0 10
X1793 74 g1793 8 b1793 NMOSWRAP
VG1794 g1794 0 2.2555114323259589
RB1794 b1794 0 10
X1794 74 g1794 9 b1794 NMOSWRAP
VG1795 g1795 0 2.8099646391566830
RB1795 b1795 0 10
X1795 74 g1795 9 b1795 NMOSWRAP
VG1796 g1796 0 2.4974446128172767
RB1796 b1796 0 10
X1796 74 g1796 9 b1796 NMOSWRAP
VG1797 g1797 0 2.1222418548595496
RB1797 b1797 0 10
X1797 74 g1797 10 b1797 NMOSWRAP
VG1798 g1798 0 2.6730943612383955
RB1798 b1798 0 10
X1798 74 g1798 10 b1798 NMOSWRAP
VG1799 g1799 0 1.5561004766024442
RB1799 b1799 0 10
X1799 74 g1799 10 b1799 NMOSWRAP
VG1800 g1800 0 2.0939001236891270
RB1800 b1800 0 10
X1800 74 g1800 11 b1800 NMOSWRAP
VG1801 g1801 0 1.5872336396068203
RB1801 b1801 0 10
X1801 74 g1801 11 b1801 NMOSWRAP
VG1802 g1802 0 2.9364087821810174
RB1802 b1802 0 10
X1802 74 g1802 11 b1802 NMOSWRAP
VG1803 g1803 0 1.4523926016840127
RB1803 b1803 0 10
X1803 74 g1803 12 b1803 NMOSWRAP
VG1804 g1804 0 1.0314764793409250
RB1804 b1804 0 10
X1804 74 g1804 12 b1804 NMOSWRAP
VG1805 g1805 0 1.6517096840075924
RB1805 b1805 0 10
X1805 74 g1805 12 b1805 NMOSWRAP
VG1806 g1806 0 2.0050187939396094
RB1806 b1806 0 10
X1806 75 g1806 3 b1806 NMOSWRAP
VG1807 g1807 0 1.0567258684601502
RB1807 b1807 0 10
X1807 75 g1807 3 b1807 NMOSWRAP
VG1808 g1808 0 2.1184966000678145
RB1808 b1808 0 10
X1808 75 g1808 3 b1808 NMOSWRAP
VG1809 g1809 0 2.7485655499024606
RB1809 b1809 0 10
X1809 75 g1809 4 b1809 NMOSWRAP
VG1810 g1810 0 2.4094643888333405
RB1810 b1810 0 10
X1810 75 g1810 4 b1810 NMOSWRAP
VG1811 g1811 0 2.2459366459566086
RB1811 b1811 0 10
X1811 75 g1811 4 b1811 NMOSWRAP
VG1812 g1812 0 2.9119235014165028
RB1812 b1812 0 10
X1812 75 g1812 5 b1812 NMOSWRAP
VG1813 g1813 0 2.9165586676842117
RB1813 b1813 0 10
X1813 75 g1813 5 b1813 NMOSWRAP
VG1814 g1814 0 2.6485329394064570
RB1814 b1814 0 10
X1814 75 g1814 5 b1814 NMOSWRAP
VG1815 g1815 0 2.2154836947717023
RB1815 b1815 0 10
X1815 75 g1815 6 b1815 NMOSWRAP
VG1816 g1816 0 1.9755291189954134
RB1816 b1816 0 10
X1816 75 g1816 6 b1816 NMOSWRAP
VG1817 g1817 0 1.0266322264929346
RB1817 b1817 0 10
X1817 75 g1817 6 b1817 NMOSWRAP
VG1818 g1818 0 2.2125238124530826
RB1818 b1818 0 10
X1818 75 g1818 7 b1818 NMOSWRAP
VG1819 g1819 0 2.9781761507137077
RB1819 b1819 0 10
X1819 75 g1819 7 b1819 NMOSWRAP
VG1820 g1820 0 2.6362021000480578
RB1820 b1820 0 10
X1820 75 g1820 7 b1820 NMOSWRAP
VG1821 g1821 0 1.6812092877687039
RB1821 b1821 0 10
X1821 75 g1821 8 b1821 NMOSWRAP
VG1822 g1822 0 1.3040940500888440
RB1822 b1822 0 10
X1822 75 g1822 8 b1822 NMOSWRAP
VG1823 g1823 0 2.5681172289343079
RB1823 b1823 0 10
X1823 75 g1823 8 b1823 NMOSWRAP
VG1824 g1824 0 2.4878756412634830
RB1824 b1824 0 10
X1824 75 g1824 9 b1824 NMOSWRAP
VG1825 g1825 0 2.9340935839586462
RB1825 b1825 0 10
X1825 75 g1825 9 b1825 NMOSWRAP
VG1826 g1826 0 2.7496847238786777
RB1826 b1826 0 10
X1826 75 g1826 9 b1826 NMOSWRAP
VG1827 g1827 0 2.1113252505448150
RB1827 b1827 0 10
X1827 75 g1827 10 b1827 NMOSWRAP
VG1828 g1828 0 1.2025684939294843
RB1828 b1828 0 10
X1828 75 g1828 10 b1828 NMOSWRAP
VG1829 g1829 0 1.9670013167679201
RB1829 b1829 0 10
X1829 75 g1829 10 b1829 NMOSWRAP
VG1830 g1830 0 1.6273901080446340
RB1830 b1830 0 10
X1830 75 g1830 11 b1830 NMOSWRAP
VG1831 g1831 0 2.0248169640496796
RB1831 b1831 0 10
X1831 75 g1831 11 b1831 NMOSWRAP
VG1832 g1832 0 1.6034031492793064
RB1832 b1832 0 10
X1832 75 g1832 11 b1832 NMOSWRAP
VG1833 g1833 0 2.7236459839511915
RB1833 b1833 0 10
X1833 75 g1833 12 b1833 NMOSWRAP
VG1834 g1834 0 2.6886540279656446
RB1834 b1834 0 10
X1834 75 g1834 12 b1834 NMOSWRAP
VG1835 g1835 0 1.6309303143341118
RB1835 b1835 0 10
X1835 75 g1835 12 b1835 NMOSWRAP
VG1836 g1836 0 2.1991626927479899
RB1836 b1836 0 10
X1836 76 g1836 3 b1836 NMOSWRAP
VG1837 g1837 0 1.8603617152781082
RB1837 b1837 0 10
X1837 76 g1837 3 b1837 NMOSWRAP
VG1838 g1838 0 2.8181855140571264
RB1838 b1838 0 10
X1838 76 g1838 3 b1838 NMOSWRAP
VG1839 g1839 0 1.3747218028526456
RB1839 b1839 0 10
X1839 76 g1839 4 b1839 NMOSWRAP
VG1840 g1840 0 2.3954568035699184
RB1840 b1840 0 10
X1840 76 g1840 4 b1840 NMOSWRAP
VG1841 g1841 0 2.9407506556744334
RB1841 b1841 0 10
X1841 76 g1841 4 b1841 NMOSWRAP
VG1842 g1842 0 1.3505510391261804
RB1842 b1842 0 10
X1842 76 g1842 5 b1842 NMOSWRAP
VG1843 g1843 0 1.4039328568484064
RB1843 b1843 0 10
X1843 76 g1843 5 b1843 NMOSWRAP
VG1844 g1844 0 2.3874466773444558
RB1844 b1844 0 10
X1844 76 g1844 5 b1844 NMOSWRAP
VG1845 g1845 0 2.5583078490498279
RB1845 b1845 0 10
X1845 76 g1845 6 b1845 NMOSWRAP
VG1846 g1846 0 1.9810981095878655
RB1846 b1846 0 10
X1846 76 g1846 6 b1846 NMOSWRAP
VG1847 g1847 0 2.2193729302942424
RB1847 b1847 0 10
X1847 76 g1847 6 b1847 NMOSWRAP
VG1848 g1848 0 1.4253648176236575
RB1848 b1848 0 10
X1848 76 g1848 7 b1848 NMOSWRAP
VG1849 g1849 0 1.9532284571346521
RB1849 b1849 0 10
X1849 76 g1849 7 b1849 NMOSWRAP
VG1850 g1850 0 1.2241437617498303
RB1850 b1850 0 10
X1850 76 g1850 7 b1850 NMOSWRAP
VG1851 g1851 0 1.6428438505513294
RB1851 b1851 0 10
X1851 76 g1851 8 b1851 NMOSWRAP
VG1852 g1852 0 1.5695594100619086
RB1852 b1852 0 10
X1852 76 g1852 8 b1852 NMOSWRAP
VG1853 g1853 0 1.8892507202048401
RB1853 b1853 0 10
X1853 76 g1853 8 b1853 NMOSWRAP
VG1854 g1854 0 2.8602527244873936
RB1854 b1854 0 10
X1854 76 g1854 9 b1854 NMOSWRAP
VG1855 g1855 0 1.3625353242956848
RB1855 b1855 0 10
X1855 76 g1855 9 b1855 NMOSWRAP
VG1856 g1856 0 1.8027764932494410
RB1856 b1856 0 10
X1856 76 g1856 9 b1856 NMOSWRAP
VG1857 g1857 0 2.2311944382192896
RB1857 b1857 0 10
X1857 76 g1857 10 b1857 NMOSWRAP
VG1858 g1858 0 2.8931141721480031
RB1858 b1858 0 10
X1858 76 g1858 10 b1858 NMOSWRAP
VG1859 g1859 0 1.2662963830715364
RB1859 b1859 0 10
X1859 76 g1859 10 b1859 NMOSWRAP
VG1860 g1860 0 2.8357532339862273
RB1860 b1860 0 10
X1860 76 g1860 11 b1860 NMOSWRAP
VG1861 g1861 0 1.1621075772681231
RB1861 b1861 0 10
X1861 76 g1861 11 b1861 NMOSWRAP
VG1862 g1862 0 1.9614827943205289
RB1862 b1862 0 10
X1862 76 g1862 11 b1862 NMOSWRAP
VG1863 g1863 0 1.9091797344609656
RB1863 b1863 0 10
X1863 76 g1863 12 b1863 NMOSWRAP
VG1864 g1864 0 1.4192054577543911
RB1864 b1864 0 10
X1864 76 g1864 12 b1864 NMOSWRAP
VG1865 g1865 0 1.6949193362316950
RB1865 b1865 0 10
X1865 76 g1865 12 b1865 NMOSWRAP
.options TEMP = 27C
.options TNOM = 27C
.options itl1=40 itl2=40 itl4=6 itl5=60
.options gmin=1e-8 reltol=5e-3 abstol=1e-8 vntol=1e-5
.options rshunt=1e9
.op
.end
