.title scikit_digits_dense_io_hinge
.include "/home/ma-lab/Desktop/pyclln-final/device_model/nmos_lvl1_ald1106.lib"
.options klu
VMINUS 1 0 0.0000000000000000
VPLUS  2 0 0.4500000000000000
VIN0 13 0 0
VIN1 14 0 0
VIN2 15 0 0
VIN3 16 0 0
VIN4 17 0 0
VIN5 18 0 0
VIN6 19 0 0
VIN7 20 0 0
VIN8 21 0 0
VIN9 22 0 0
VIN10 23 0 0
VIN11 24 0 0
VIN12 25 0 0
VIN13 26 0 0
VIN14 27 0 0
VIN15 28 0 0
VIN16 29 0 0
VIN17 30 0 0
VIN18 31 0 0
VIN19 32 0 0
VIN20 33 0 0
VIN21 34 0 0
VIN22 35 0 0
VIN23 36 0 0
VIN24 37 0 0
VIN25 38 0 0
VIN26 39 0 0
VIN27 40 0 0
VIN28 41 0 0
VIN29 42 0 0
VIN30 43 0 0
VIN31 44 0 0
VIN32 45 0 0
VIN33 46 0 0
VIN34 47 0 0
VIN35 48 0 0
VIN36 49 0 0
VIN37 50 0 0
VIN38 51 0 0
VIN39 52 0 0
VIN40 53 0 0
VIN41 54 0 0
VIN42 55 0 0
VIN43 56 0 0
VIN44 57 0 0
VIN45 58 0 0
VIN46 59 0 0
VIN47 60 0 0
VIN48 61 0 0
VIN49 62 0 0
VIN50 63 0 0
VIN51 64 0 0
VIN52 65 0 0
VIN53 66 0 0
VIN54 67 0 0
VIN55 68 0 0
VIN56 69 0 0
VIN57 70 0 0
VIN58 71 0 0
VIN59 72 0 0
VIN60 73 0 0
VIN61 74 0 0
VIN62 75 0 0
VIN63 76 0 0
RS1 3 77 1e+09
RS2 4 78 1e+09
RS3 5 79 1e+09
RS4 6 80 1e+09
RS5 7 81 1e+09
RS6 8 82 1e+09
RS7 9 83 1e+09
RS8 10 84 1e+09
RS9 11 85 1e+09
RS10 12 86 1e+09
VOUT0 77 0 0
VOUT1 78 0 0
VOUT2 79 0 0
VOUT3 80 0 0
VOUT4 81 0 0
VOUT5 82 0 0
VOUT6 83 0 0
VOUT7 84 0 0
VOUT8 85 0 0
VOUT9 86 0 0
VG0 g0 0 0.6000000000000000
RB0 b0 0 10
X0 13 g0 3 b0 NMOSWRAP
VG1 g1 0 0.6000000000000000
RB1 b1 0 10
X1 13 g1 3 b1 NMOSWRAP
VG2 g2 0 0.6000000000000000
RB2 b2 0 10
X2 13 g2 3 b2 NMOSWRAP
VG3 g3 0 0.6000000000000000
RB3 b3 0 10
X3 13 g3 4 b3 NMOSWRAP
VG4 g4 0 0.6000000000000000
RB4 b4 0 10
X4 13 g4 4 b4 NMOSWRAP
VG5 g5 0 0.6000000000000000
RB5 b5 0 10
X5 13 g5 4 b5 NMOSWRAP
VG6 g6 0 0.6000000000000000
RB6 b6 0 10
X6 13 g6 5 b6 NMOSWRAP
VG7 g7 0 0.6000000000000000
RB7 b7 0 10
X7 13 g7 5 b7 NMOSWRAP
VG8 g8 0 0.6000000000000000
RB8 b8 0 10
X8 13 g8 5 b8 NMOSWRAP
VG9 g9 0 0.6000000000000000
RB9 b9 0 10
X9 13 g9 6 b9 NMOSWRAP
VG10 g10 0 0.6000000000000000
RB10 b10 0 10
X10 13 g10 6 b10 NMOSWRAP
VG11 g11 0 0.6000000000000000
RB11 b11 0 10
X11 13 g11 6 b11 NMOSWRAP
VG12 g12 0 0.6000000000000000
RB12 b12 0 10
X12 13 g12 7 b12 NMOSWRAP
VG13 g13 0 0.6000000000000000
RB13 b13 0 10
X13 13 g13 7 b13 NMOSWRAP
VG14 g14 0 0.6000000000000000
RB14 b14 0 10
X14 13 g14 7 b14 NMOSWRAP
VG15 g15 0 0.6000000000000000
RB15 b15 0 10
X15 13 g15 8 b15 NMOSWRAP
VG16 g16 0 0.6000000000000000
RB16 b16 0 10
X16 13 g16 8 b16 NMOSWRAP
VG17 g17 0 0.6000000000000000
RB17 b17 0 10
X17 13 g17 8 b17 NMOSWRAP
VG18 g18 0 0.6000000000000000
RB18 b18 0 10
X18 13 g18 9 b18 NMOSWRAP
VG19 g19 0 0.6000000000000000
RB19 b19 0 10
X19 13 g19 9 b19 NMOSWRAP
VG20 g20 0 0.6000000000000000
RB20 b20 0 10
X20 13 g20 9 b20 NMOSWRAP
VG21 g21 0 0.6000000000000000
RB21 b21 0 10
X21 13 g21 10 b21 NMOSWRAP
VG22 g22 0 0.6000000000000000
RB22 b22 0 10
X22 13 g22 10 b22 NMOSWRAP
VG23 g23 0 0.6000000000000000
RB23 b23 0 10
X23 13 g23 10 b23 NMOSWRAP
VG24 g24 0 0.6000000000000000
RB24 b24 0 10
X24 13 g24 11 b24 NMOSWRAP
VG25 g25 0 0.6000000000000000
RB25 b25 0 10
X25 13 g25 11 b25 NMOSWRAP
VG26 g26 0 0.6000000000000000
RB26 b26 0 10
X26 13 g26 11 b26 NMOSWRAP
VG27 g27 0 0.6000000000000000
RB27 b27 0 10
X27 13 g27 12 b27 NMOSWRAP
VG28 g28 0 0.6000000000000000
RB28 b28 0 10
X28 13 g28 12 b28 NMOSWRAP
VG29 g29 0 0.6000000000000000
RB29 b29 0 10
X29 13 g29 12 b29 NMOSWRAP
VG30 g30 0 0.6000000000000000
RB30 b30 0 10
X30 14 g30 3 b30 NMOSWRAP
VG31 g31 0 0.6000000000000000
RB31 b31 0 10
X31 14 g31 3 b31 NMOSWRAP
VG32 g32 0 0.6000000000000000
RB32 b32 0 10
X32 14 g32 3 b32 NMOSWRAP
VG33 g33 0 0.6000000000000000
RB33 b33 0 10
X33 14 g33 4 b33 NMOSWRAP
VG34 g34 0 0.6000000000000000
RB34 b34 0 10
X34 14 g34 4 b34 NMOSWRAP
VG35 g35 0 0.6000000000000000
RB35 b35 0 10
X35 14 g35 4 b35 NMOSWRAP
VG36 g36 0 0.6000000000000000
RB36 b36 0 10
X36 14 g36 5 b36 NMOSWRAP
VG37 g37 0 0.6000000000000000
RB37 b37 0 10
X37 14 g37 5 b37 NMOSWRAP
VG38 g38 0 0.6000000000000000
RB38 b38 0 10
X38 14 g38 5 b38 NMOSWRAP
VG39 g39 0 0.6000000000000000
RB39 b39 0 10
X39 14 g39 6 b39 NMOSWRAP
VG40 g40 0 0.6000000000000000
RB40 b40 0 10
X40 14 g40 6 b40 NMOSWRAP
VG41 g41 0 0.6000000000000000
RB41 b41 0 10
X41 14 g41 6 b41 NMOSWRAP
VG42 g42 0 0.6000000000000000
RB42 b42 0 10
X42 14 g42 7 b42 NMOSWRAP
VG43 g43 0 0.6000000000000000
RB43 b43 0 10
X43 14 g43 7 b43 NMOSWRAP
VG44 g44 0 0.6000000000000000
RB44 b44 0 10
X44 14 g44 7 b44 NMOSWRAP
VG45 g45 0 0.6000000000000000
RB45 b45 0 10
X45 14 g45 8 b45 NMOSWRAP
VG46 g46 0 0.6000000000000000
RB46 b46 0 10
X46 14 g46 8 b46 NMOSWRAP
VG47 g47 0 0.6000000000000000
RB47 b47 0 10
X47 14 g47 8 b47 NMOSWRAP
VG48 g48 0 0.6000000000000000
RB48 b48 0 10
X48 14 g48 9 b48 NMOSWRAP
VG49 g49 0 0.6000000000000000
RB49 b49 0 10
X49 14 g49 9 b49 NMOSWRAP
VG50 g50 0 0.6000000000000000
RB50 b50 0 10
X50 14 g50 9 b50 NMOSWRAP
VG51 g51 0 0.6000000000000000
RB51 b51 0 10
X51 14 g51 10 b51 NMOSWRAP
VG52 g52 0 0.6000000000000000
RB52 b52 0 10
X52 14 g52 10 b52 NMOSWRAP
VG53 g53 0 0.6000000000000000
RB53 b53 0 10
X53 14 g53 10 b53 NMOSWRAP
VG54 g54 0 0.6000000000000000
RB54 b54 0 10
X54 14 g54 11 b54 NMOSWRAP
VG55 g55 0 0.6000000000000000
RB55 b55 0 10
X55 14 g55 11 b55 NMOSWRAP
VG56 g56 0 0.6000000000000000
RB56 b56 0 10
X56 14 g56 11 b56 NMOSWRAP
VG57 g57 0 0.6000000000000000
RB57 b57 0 10
X57 14 g57 12 b57 NMOSWRAP
VG58 g58 0 0.6000000000000000
RB58 b58 0 10
X58 14 g58 12 b58 NMOSWRAP
VG59 g59 0 0.6000000000000000
RB59 b59 0 10
X59 14 g59 12 b59 NMOSWRAP
VG60 g60 0 0.6000000000000000
RB60 b60 0 10
X60 15 g60 3 b60 NMOSWRAP
VG61 g61 0 0.6000000000000000
RB61 b61 0 10
X61 15 g61 3 b61 NMOSWRAP
VG62 g62 0 0.6000000000000000
RB62 b62 0 10
X62 15 g62 3 b62 NMOSWRAP
VG63 g63 0 0.6000000000000000
RB63 b63 0 10
X63 15 g63 4 b63 NMOSWRAP
VG64 g64 0 0.6000000000000000
RB64 b64 0 10
X64 15 g64 4 b64 NMOSWRAP
VG65 g65 0 0.6000000000000000
RB65 b65 0 10
X65 15 g65 4 b65 NMOSWRAP
VG66 g66 0 0.6000000000000000
RB66 b66 0 10
X66 15 g66 5 b66 NMOSWRAP
VG67 g67 0 0.6000000000000000
RB67 b67 0 10
X67 15 g67 5 b67 NMOSWRAP
VG68 g68 0 0.6000000000000000
RB68 b68 0 10
X68 15 g68 5 b68 NMOSWRAP
VG69 g69 0 0.6000000000000000
RB69 b69 0 10
X69 15 g69 6 b69 NMOSWRAP
VG70 g70 0 0.6000000000000000
RB70 b70 0 10
X70 15 g70 6 b70 NMOSWRAP
VG71 g71 0 0.6000000000000000
RB71 b71 0 10
X71 15 g71 6 b71 NMOSWRAP
VG72 g72 0 0.6000000000000000
RB72 b72 0 10
X72 15 g72 7 b72 NMOSWRAP
VG73 g73 0 0.6000000000000000
RB73 b73 0 10
X73 15 g73 7 b73 NMOSWRAP
VG74 g74 0 0.6000000000000000
RB74 b74 0 10
X74 15 g74 7 b74 NMOSWRAP
VG75 g75 0 0.6000000000000000
RB75 b75 0 10
X75 15 g75 8 b75 NMOSWRAP
VG76 g76 0 0.6000000000000000
RB76 b76 0 10
X76 15 g76 8 b76 NMOSWRAP
VG77 g77 0 0.6000000000000000
RB77 b77 0 10
X77 15 g77 8 b77 NMOSWRAP
VG78 g78 0 0.6000000000000000
RB78 b78 0 10
X78 15 g78 9 b78 NMOSWRAP
VG79 g79 0 0.6000000000000000
RB79 b79 0 10
X79 15 g79 9 b79 NMOSWRAP
VG80 g80 0 0.6000000000000000
RB80 b80 0 10
X80 15 g80 9 b80 NMOSWRAP
VG81 g81 0 0.6000000000000000
RB81 b81 0 10
X81 15 g81 10 b81 NMOSWRAP
VG82 g82 0 0.6000000000000000
RB82 b82 0 10
X82 15 g82 10 b82 NMOSWRAP
VG83 g83 0 0.6000000000000000
RB83 b83 0 10
X83 15 g83 10 b83 NMOSWRAP
VG84 g84 0 0.6000000000000000
RB84 b84 0 10
X84 15 g84 11 b84 NMOSWRAP
VG85 g85 0 0.6000000000000000
RB85 b85 0 10
X85 15 g85 11 b85 NMOSWRAP
VG86 g86 0 0.6000000000000000
RB86 b86 0 10
X86 15 g86 11 b86 NMOSWRAP
VG87 g87 0 0.6000000000000000
RB87 b87 0 10
X87 15 g87 12 b87 NMOSWRAP
VG88 g88 0 0.6000000000000000
RB88 b88 0 10
X88 15 g88 12 b88 NMOSWRAP
VG89 g89 0 0.6000000000000000
RB89 b89 0 10
X89 15 g89 12 b89 NMOSWRAP
VG90 g90 0 0.6000000000000000
RB90 b90 0 10
X90 16 g90 3 b90 NMOSWRAP
VG91 g91 0 0.6000000000000000
RB91 b91 0 10
X91 16 g91 3 b91 NMOSWRAP
VG92 g92 0 0.6000000000000000
RB92 b92 0 10
X92 16 g92 3 b92 NMOSWRAP
VG93 g93 0 0.6000000000000000
RB93 b93 0 10
X93 16 g93 4 b93 NMOSWRAP
VG94 g94 0 0.6000000000000000
RB94 b94 0 10
X94 16 g94 4 b94 NMOSWRAP
VG95 g95 0 0.6000000000000000
RB95 b95 0 10
X95 16 g95 4 b95 NMOSWRAP
VG96 g96 0 0.6000000000000000
RB96 b96 0 10
X96 16 g96 5 b96 NMOSWRAP
VG97 g97 0 0.6000000000000000
RB97 b97 0 10
X97 16 g97 5 b97 NMOSWRAP
VG98 g98 0 0.6000000000000000
RB98 b98 0 10
X98 16 g98 5 b98 NMOSWRAP
VG99 g99 0 0.6000000000000000
RB99 b99 0 10
X99 16 g99 6 b99 NMOSWRAP
VG100 g100 0 0.6000000000000000
RB100 b100 0 10
X100 16 g100 6 b100 NMOSWRAP
VG101 g101 0 0.6000000000000000
RB101 b101 0 10
X101 16 g101 6 b101 NMOSWRAP
VG102 g102 0 0.6000000000000000
RB102 b102 0 10
X102 16 g102 7 b102 NMOSWRAP
VG103 g103 0 0.6000000000000000
RB103 b103 0 10
X103 16 g103 7 b103 NMOSWRAP
VG104 g104 0 0.6000000000000000
RB104 b104 0 10
X104 16 g104 7 b104 NMOSWRAP
VG105 g105 0 0.6000000000000000
RB105 b105 0 10
X105 16 g105 8 b105 NMOSWRAP
VG106 g106 0 0.6000000000000000
RB106 b106 0 10
X106 16 g106 8 b106 NMOSWRAP
VG107 g107 0 0.6000000000000000
RB107 b107 0 10
X107 16 g107 8 b107 NMOSWRAP
VG108 g108 0 0.6000000000000000
RB108 b108 0 10
X108 16 g108 9 b108 NMOSWRAP
VG109 g109 0 0.6000000000000000
RB109 b109 0 10
X109 16 g109 9 b109 NMOSWRAP
VG110 g110 0 0.6000000000000000
RB110 b110 0 10
X110 16 g110 9 b110 NMOSWRAP
VG111 g111 0 0.6000000000000000
RB111 b111 0 10
X111 16 g111 10 b111 NMOSWRAP
VG112 g112 0 0.6000000000000000
RB112 b112 0 10
X112 16 g112 10 b112 NMOSWRAP
VG113 g113 0 0.6000000000000000
RB113 b113 0 10
X113 16 g113 10 b113 NMOSWRAP
VG114 g114 0 0.6000000000000000
RB114 b114 0 10
X114 16 g114 11 b114 NMOSWRAP
VG115 g115 0 0.6000000000000000
RB115 b115 0 10
X115 16 g115 11 b115 NMOSWRAP
VG116 g116 0 0.6000000000000000
RB116 b116 0 10
X116 16 g116 11 b116 NMOSWRAP
VG117 g117 0 0.6000000000000000
RB117 b117 0 10
X117 16 g117 12 b117 NMOSWRAP
VG118 g118 0 0.6000000000000000
RB118 b118 0 10
X118 16 g118 12 b118 NMOSWRAP
VG119 g119 0 0.6000000000000000
RB119 b119 0 10
X119 16 g119 12 b119 NMOSWRAP
VG120 g120 0 0.6000000000000000
RB120 b120 0 10
X120 17 g120 3 b120 NMOSWRAP
VG121 g121 0 0.6000000000000000
RB121 b121 0 10
X121 17 g121 3 b121 NMOSWRAP
VG122 g122 0 0.6000000000000000
RB122 b122 0 10
X122 17 g122 3 b122 NMOSWRAP
VG123 g123 0 0.6000000000000000
RB123 b123 0 10
X123 17 g123 4 b123 NMOSWRAP
VG124 g124 0 0.6000000000000000
RB124 b124 0 10
X124 17 g124 4 b124 NMOSWRAP
VG125 g125 0 0.6000000000000000
RB125 b125 0 10
X125 17 g125 4 b125 NMOSWRAP
VG126 g126 0 0.6000000000000000
RB126 b126 0 10
X126 17 g126 5 b126 NMOSWRAP
VG127 g127 0 0.6000000000000000
RB127 b127 0 10
X127 17 g127 5 b127 NMOSWRAP
VG128 g128 0 0.6000000000000000
RB128 b128 0 10
X128 17 g128 5 b128 NMOSWRAP
VG129 g129 0 0.6000000000000000
RB129 b129 0 10
X129 17 g129 6 b129 NMOSWRAP
VG130 g130 0 0.6000000000000000
RB130 b130 0 10
X130 17 g130 6 b130 NMOSWRAP
VG131 g131 0 0.6000000000000000
RB131 b131 0 10
X131 17 g131 6 b131 NMOSWRAP
VG132 g132 0 0.6000000000000000
RB132 b132 0 10
X132 17 g132 7 b132 NMOSWRAP
VG133 g133 0 0.6000000000000000
RB133 b133 0 10
X133 17 g133 7 b133 NMOSWRAP
VG134 g134 0 0.6000000000000000
RB134 b134 0 10
X134 17 g134 7 b134 NMOSWRAP
VG135 g135 0 0.6000000000000000
RB135 b135 0 10
X135 17 g135 8 b135 NMOSWRAP
VG136 g136 0 0.6000000000000000
RB136 b136 0 10
X136 17 g136 8 b136 NMOSWRAP
VG137 g137 0 0.6000000000000000
RB137 b137 0 10
X137 17 g137 8 b137 NMOSWRAP
VG138 g138 0 0.6000000000000000
RB138 b138 0 10
X138 17 g138 9 b138 NMOSWRAP
VG139 g139 0 0.6000000000000000
RB139 b139 0 10
X139 17 g139 9 b139 NMOSWRAP
VG140 g140 0 0.6000000000000000
RB140 b140 0 10
X140 17 g140 9 b140 NMOSWRAP
VG141 g141 0 0.6000000000000000
RB141 b141 0 10
X141 17 g141 10 b141 NMOSWRAP
VG142 g142 0 0.6000000000000000
RB142 b142 0 10
X142 17 g142 10 b142 NMOSWRAP
VG143 g143 0 0.6000000000000000
RB143 b143 0 10
X143 17 g143 10 b143 NMOSWRAP
VG144 g144 0 0.6000000000000000
RB144 b144 0 10
X144 17 g144 11 b144 NMOSWRAP
VG145 g145 0 0.6000000000000000
RB145 b145 0 10
X145 17 g145 11 b145 NMOSWRAP
VG146 g146 0 0.6000000000000000
RB146 b146 0 10
X146 17 g146 11 b146 NMOSWRAP
VG147 g147 0 0.6000000000000000
RB147 b147 0 10
X147 17 g147 12 b147 NMOSWRAP
VG148 g148 0 0.6000000000000000
RB148 b148 0 10
X148 17 g148 12 b148 NMOSWRAP
VG149 g149 0 0.6000000000000000
RB149 b149 0 10
X149 17 g149 12 b149 NMOSWRAP
VG150 g150 0 0.6000000000000000
RB150 b150 0 10
X150 18 g150 3 b150 NMOSWRAP
VG151 g151 0 0.6000000000000000
RB151 b151 0 10
X151 18 g151 3 b151 NMOSWRAP
VG152 g152 0 0.6000000000000000
RB152 b152 0 10
X152 18 g152 3 b152 NMOSWRAP
VG153 g153 0 0.6000000000000000
RB153 b153 0 10
X153 18 g153 4 b153 NMOSWRAP
VG154 g154 0 0.6000000000000000
RB154 b154 0 10
X154 18 g154 4 b154 NMOSWRAP
VG155 g155 0 0.6000000000000000
RB155 b155 0 10
X155 18 g155 4 b155 NMOSWRAP
VG156 g156 0 0.6000000000000000
RB156 b156 0 10
X156 18 g156 5 b156 NMOSWRAP
VG157 g157 0 0.6000000000000000
RB157 b157 0 10
X157 18 g157 5 b157 NMOSWRAP
VG158 g158 0 0.6000000000000000
RB158 b158 0 10
X158 18 g158 5 b158 NMOSWRAP
VG159 g159 0 0.6000000000000000
RB159 b159 0 10
X159 18 g159 6 b159 NMOSWRAP
VG160 g160 0 0.6000000000000000
RB160 b160 0 10
X160 18 g160 6 b160 NMOSWRAP
VG161 g161 0 0.6000000000000000
RB161 b161 0 10
X161 18 g161 6 b161 NMOSWRAP
VG162 g162 0 0.6000000000000000
RB162 b162 0 10
X162 18 g162 7 b162 NMOSWRAP
VG163 g163 0 0.6000000000000000
RB163 b163 0 10
X163 18 g163 7 b163 NMOSWRAP
VG164 g164 0 0.6000000000000000
RB164 b164 0 10
X164 18 g164 7 b164 NMOSWRAP
VG165 g165 0 0.6000000000000000
RB165 b165 0 10
X165 18 g165 8 b165 NMOSWRAP
VG166 g166 0 0.6000000000000000
RB166 b166 0 10
X166 18 g166 8 b166 NMOSWRAP
VG167 g167 0 0.6000000000000000
RB167 b167 0 10
X167 18 g167 8 b167 NMOSWRAP
VG168 g168 0 0.6000000000000000
RB168 b168 0 10
X168 18 g168 9 b168 NMOSWRAP
VG169 g169 0 0.6000000000000000
RB169 b169 0 10
X169 18 g169 9 b169 NMOSWRAP
VG170 g170 0 0.6000000000000000
RB170 b170 0 10
X170 18 g170 9 b170 NMOSWRAP
VG171 g171 0 0.6000000000000000
RB171 b171 0 10
X171 18 g171 10 b171 NMOSWRAP
VG172 g172 0 0.6000000000000000
RB172 b172 0 10
X172 18 g172 10 b172 NMOSWRAP
VG173 g173 0 0.6000000000000000
RB173 b173 0 10
X173 18 g173 10 b173 NMOSWRAP
VG174 g174 0 0.6000000000000000
RB174 b174 0 10
X174 18 g174 11 b174 NMOSWRAP
VG175 g175 0 0.6000000000000000
RB175 b175 0 10
X175 18 g175 11 b175 NMOSWRAP
VG176 g176 0 0.6000000000000000
RB176 b176 0 10
X176 18 g176 11 b176 NMOSWRAP
VG177 g177 0 0.6000000000000000
RB177 b177 0 10
X177 18 g177 12 b177 NMOSWRAP
VG178 g178 0 0.6000000000000000
RB178 b178 0 10
X178 18 g178 12 b178 NMOSWRAP
VG179 g179 0 0.6000000000000000
RB179 b179 0 10
X179 18 g179 12 b179 NMOSWRAP
VG180 g180 0 0.6000000000000000
RB180 b180 0 10
X180 19 g180 3 b180 NMOSWRAP
VG181 g181 0 0.6000000000000000
RB181 b181 0 10
X181 19 g181 3 b181 NMOSWRAP
VG182 g182 0 0.6000000000000000
RB182 b182 0 10
X182 19 g182 3 b182 NMOSWRAP
VG183 g183 0 0.6000000000000000
RB183 b183 0 10
X183 19 g183 4 b183 NMOSWRAP
VG184 g184 0 0.6000000000000000
RB184 b184 0 10
X184 19 g184 4 b184 NMOSWRAP
VG185 g185 0 0.6000000000000000
RB185 b185 0 10
X185 19 g185 4 b185 NMOSWRAP
VG186 g186 0 0.6000000000000000
RB186 b186 0 10
X186 19 g186 5 b186 NMOSWRAP
VG187 g187 0 0.6000000000000000
RB187 b187 0 10
X187 19 g187 5 b187 NMOSWRAP
VG188 g188 0 0.6000000000000000
RB188 b188 0 10
X188 19 g188 5 b188 NMOSWRAP
VG189 g189 0 0.6000000000000000
RB189 b189 0 10
X189 19 g189 6 b189 NMOSWRAP
VG190 g190 0 0.6000000000000000
RB190 b190 0 10
X190 19 g190 6 b190 NMOSWRAP
VG191 g191 0 0.6000000000000000
RB191 b191 0 10
X191 19 g191 6 b191 NMOSWRAP
VG192 g192 0 0.6000000000000000
RB192 b192 0 10
X192 19 g192 7 b192 NMOSWRAP
VG193 g193 0 0.6000000000000000
RB193 b193 0 10
X193 19 g193 7 b193 NMOSWRAP
VG194 g194 0 0.6000000000000000
RB194 b194 0 10
X194 19 g194 7 b194 NMOSWRAP
VG195 g195 0 0.6000000000000000
RB195 b195 0 10
X195 19 g195 8 b195 NMOSWRAP
VG196 g196 0 0.6000000000000000
RB196 b196 0 10
X196 19 g196 8 b196 NMOSWRAP
VG197 g197 0 0.6000000000000000
RB197 b197 0 10
X197 19 g197 8 b197 NMOSWRAP
VG198 g198 0 0.6000000000000000
RB198 b198 0 10
X198 19 g198 9 b198 NMOSWRAP
VG199 g199 0 0.6000000000000000
RB199 b199 0 10
X199 19 g199 9 b199 NMOSWRAP
VG200 g200 0 0.6000000000000000
RB200 b200 0 10
X200 19 g200 9 b200 NMOSWRAP
VG201 g201 0 0.6000000000000000
RB201 b201 0 10
X201 19 g201 10 b201 NMOSWRAP
VG202 g202 0 0.6000000000000000
RB202 b202 0 10
X202 19 g202 10 b202 NMOSWRAP
VG203 g203 0 0.6000000000000000
RB203 b203 0 10
X203 19 g203 10 b203 NMOSWRAP
VG204 g204 0 0.6000000000000000
RB204 b204 0 10
X204 19 g204 11 b204 NMOSWRAP
VG205 g205 0 0.6000000000000000
RB205 b205 0 10
X205 19 g205 11 b205 NMOSWRAP
VG206 g206 0 0.6000000000000000
RB206 b206 0 10
X206 19 g206 11 b206 NMOSWRAP
VG207 g207 0 0.6000000000000000
RB207 b207 0 10
X207 19 g207 12 b207 NMOSWRAP
VG208 g208 0 0.6000000000000000
RB208 b208 0 10
X208 19 g208 12 b208 NMOSWRAP
VG209 g209 0 0.6000000000000000
RB209 b209 0 10
X209 19 g209 12 b209 NMOSWRAP
VG210 g210 0 0.6000000000000000
RB210 b210 0 10
X210 20 g210 3 b210 NMOSWRAP
VG211 g211 0 0.6000000000000000
RB211 b211 0 10
X211 20 g211 3 b211 NMOSWRAP
VG212 g212 0 0.6000000000000000
RB212 b212 0 10
X212 20 g212 3 b212 NMOSWRAP
VG213 g213 0 0.6000000000000000
RB213 b213 0 10
X213 20 g213 4 b213 NMOSWRAP
VG214 g214 0 0.6000000000000000
RB214 b214 0 10
X214 20 g214 4 b214 NMOSWRAP
VG215 g215 0 0.6000000000000000
RB215 b215 0 10
X215 20 g215 4 b215 NMOSWRAP
VG216 g216 0 0.6000000000000000
RB216 b216 0 10
X216 20 g216 5 b216 NMOSWRAP
VG217 g217 0 0.6000000000000000
RB217 b217 0 10
X217 20 g217 5 b217 NMOSWRAP
VG218 g218 0 0.6000000000000000
RB218 b218 0 10
X218 20 g218 5 b218 NMOSWRAP
VG219 g219 0 0.6000000000000000
RB219 b219 0 10
X219 20 g219 6 b219 NMOSWRAP
VG220 g220 0 0.6000000000000000
RB220 b220 0 10
X220 20 g220 6 b220 NMOSWRAP
VG221 g221 0 0.6000000000000000
RB221 b221 0 10
X221 20 g221 6 b221 NMOSWRAP
VG222 g222 0 0.6000000000000000
RB222 b222 0 10
X222 20 g222 7 b222 NMOSWRAP
VG223 g223 0 0.6000000000000000
RB223 b223 0 10
X223 20 g223 7 b223 NMOSWRAP
VG224 g224 0 0.6000000000000000
RB224 b224 0 10
X224 20 g224 7 b224 NMOSWRAP
VG225 g225 0 0.6000000000000000
RB225 b225 0 10
X225 20 g225 8 b225 NMOSWRAP
VG226 g226 0 0.6000000000000000
RB226 b226 0 10
X226 20 g226 8 b226 NMOSWRAP
VG227 g227 0 0.6000000000000000
RB227 b227 0 10
X227 20 g227 8 b227 NMOSWRAP
VG228 g228 0 0.6000000000000000
RB228 b228 0 10
X228 20 g228 9 b228 NMOSWRAP
VG229 g229 0 0.6000000000000000
RB229 b229 0 10
X229 20 g229 9 b229 NMOSWRAP
VG230 g230 0 0.6000000000000000
RB230 b230 0 10
X230 20 g230 9 b230 NMOSWRAP
VG231 g231 0 0.6000000000000000
RB231 b231 0 10
X231 20 g231 10 b231 NMOSWRAP
VG232 g232 0 0.6000000000000000
RB232 b232 0 10
X232 20 g232 10 b232 NMOSWRAP
VG233 g233 0 0.6000000000000000
RB233 b233 0 10
X233 20 g233 10 b233 NMOSWRAP
VG234 g234 0 0.6000000000000000
RB234 b234 0 10
X234 20 g234 11 b234 NMOSWRAP
VG235 g235 0 0.6000000000000000
RB235 b235 0 10
X235 20 g235 11 b235 NMOSWRAP
VG236 g236 0 0.6000000000000000
RB236 b236 0 10
X236 20 g236 11 b236 NMOSWRAP
VG237 g237 0 0.6000000000000000
RB237 b237 0 10
X237 20 g237 12 b237 NMOSWRAP
VG238 g238 0 0.6000000000000000
RB238 b238 0 10
X238 20 g238 12 b238 NMOSWRAP
VG239 g239 0 0.6000000000000000
RB239 b239 0 10
X239 20 g239 12 b239 NMOSWRAP
VG240 g240 0 0.6000000000000000
RB240 b240 0 10
X240 21 g240 3 b240 NMOSWRAP
VG241 g241 0 0.6000000000000000
RB241 b241 0 10
X241 21 g241 3 b241 NMOSWRAP
VG242 g242 0 0.6000000000000000
RB242 b242 0 10
X242 21 g242 3 b242 NMOSWRAP
VG243 g243 0 0.6000000000000000
RB243 b243 0 10
X243 21 g243 4 b243 NMOSWRAP
VG244 g244 0 0.6000000000000000
RB244 b244 0 10
X244 21 g244 4 b244 NMOSWRAP
VG245 g245 0 0.6000000000000000
RB245 b245 0 10
X245 21 g245 4 b245 NMOSWRAP
VG246 g246 0 0.6000000000000000
RB246 b246 0 10
X246 21 g246 5 b246 NMOSWRAP
VG247 g247 0 0.6000000000000000
RB247 b247 0 10
X247 21 g247 5 b247 NMOSWRAP
VG248 g248 0 0.6000000000000000
RB248 b248 0 10
X248 21 g248 5 b248 NMOSWRAP
VG249 g249 0 0.6000000000000000
RB249 b249 0 10
X249 21 g249 6 b249 NMOSWRAP
VG250 g250 0 0.6000000000000000
RB250 b250 0 10
X250 21 g250 6 b250 NMOSWRAP
VG251 g251 0 0.6000000000000000
RB251 b251 0 10
X251 21 g251 6 b251 NMOSWRAP
VG252 g252 0 0.6000000000000000
RB252 b252 0 10
X252 21 g252 7 b252 NMOSWRAP
VG253 g253 0 0.6000000000000000
RB253 b253 0 10
X253 21 g253 7 b253 NMOSWRAP
VG254 g254 0 0.6000000000000000
RB254 b254 0 10
X254 21 g254 7 b254 NMOSWRAP
VG255 g255 0 0.6000000000000000
RB255 b255 0 10
X255 21 g255 8 b255 NMOSWRAP
VG256 g256 0 0.6000000000000000
RB256 b256 0 10
X256 21 g256 8 b256 NMOSWRAP
VG257 g257 0 0.6000000000000000
RB257 b257 0 10
X257 21 g257 8 b257 NMOSWRAP
VG258 g258 0 0.6000000000000000
RB258 b258 0 10
X258 21 g258 9 b258 NMOSWRAP
VG259 g259 0 0.6000000000000000
RB259 b259 0 10
X259 21 g259 9 b259 NMOSWRAP
VG260 g260 0 0.6000000000000000
RB260 b260 0 10
X260 21 g260 9 b260 NMOSWRAP
VG261 g261 0 0.6000000000000000
RB261 b261 0 10
X261 21 g261 10 b261 NMOSWRAP
VG262 g262 0 0.6000000000000000
RB262 b262 0 10
X262 21 g262 10 b262 NMOSWRAP
VG263 g263 0 0.6000000000000000
RB263 b263 0 10
X263 21 g263 10 b263 NMOSWRAP
VG264 g264 0 0.6000000000000000
RB264 b264 0 10
X264 21 g264 11 b264 NMOSWRAP
VG265 g265 0 0.6000000000000000
RB265 b265 0 10
X265 21 g265 11 b265 NMOSWRAP
VG266 g266 0 0.6000000000000000
RB266 b266 0 10
X266 21 g266 11 b266 NMOSWRAP
VG267 g267 0 0.6000000000000000
RB267 b267 0 10
X267 21 g267 12 b267 NMOSWRAP
VG268 g268 0 0.6000000000000000
RB268 b268 0 10
X268 21 g268 12 b268 NMOSWRAP
VG269 g269 0 0.6000000000000000
RB269 b269 0 10
X269 21 g269 12 b269 NMOSWRAP
VG270 g270 0 0.6000000000000000
RB270 b270 0 10
X270 22 g270 3 b270 NMOSWRAP
VG271 g271 0 0.6000000000000000
RB271 b271 0 10
X271 22 g271 3 b271 NMOSWRAP
VG272 g272 0 0.6000000000000000
RB272 b272 0 10
X272 22 g272 3 b272 NMOSWRAP
VG273 g273 0 0.6000000000000000
RB273 b273 0 10
X273 22 g273 4 b273 NMOSWRAP
VG274 g274 0 0.6000000000000000
RB274 b274 0 10
X274 22 g274 4 b274 NMOSWRAP
VG275 g275 0 0.6000000000000000
RB275 b275 0 10
X275 22 g275 4 b275 NMOSWRAP
VG276 g276 0 0.6000000000000000
RB276 b276 0 10
X276 22 g276 5 b276 NMOSWRAP
VG277 g277 0 0.6000000000000000
RB277 b277 0 10
X277 22 g277 5 b277 NMOSWRAP
VG278 g278 0 0.6000000000000000
RB278 b278 0 10
X278 22 g278 5 b278 NMOSWRAP
VG279 g279 0 0.6000000000000000
RB279 b279 0 10
X279 22 g279 6 b279 NMOSWRAP
VG280 g280 0 0.6000000000000000
RB280 b280 0 10
X280 22 g280 6 b280 NMOSWRAP
VG281 g281 0 0.6000000000000000
RB281 b281 0 10
X281 22 g281 6 b281 NMOSWRAP
VG282 g282 0 0.6000000000000000
RB282 b282 0 10
X282 22 g282 7 b282 NMOSWRAP
VG283 g283 0 0.6000000000000000
RB283 b283 0 10
X283 22 g283 7 b283 NMOSWRAP
VG284 g284 0 0.6000000000000000
RB284 b284 0 10
X284 22 g284 7 b284 NMOSWRAP
VG285 g285 0 0.6000000000000000
RB285 b285 0 10
X285 22 g285 8 b285 NMOSWRAP
VG286 g286 0 0.6000000000000000
RB286 b286 0 10
X286 22 g286 8 b286 NMOSWRAP
VG287 g287 0 0.6000000000000000
RB287 b287 0 10
X287 22 g287 8 b287 NMOSWRAP
VG288 g288 0 0.6000000000000000
RB288 b288 0 10
X288 22 g288 9 b288 NMOSWRAP
VG289 g289 0 0.6000000000000000
RB289 b289 0 10
X289 22 g289 9 b289 NMOSWRAP
VG290 g290 0 0.6000000000000000
RB290 b290 0 10
X290 22 g290 9 b290 NMOSWRAP
VG291 g291 0 0.6000000000000000
RB291 b291 0 10
X291 22 g291 10 b291 NMOSWRAP
VG292 g292 0 0.6000000000000000
RB292 b292 0 10
X292 22 g292 10 b292 NMOSWRAP
VG293 g293 0 0.6000000000000000
RB293 b293 0 10
X293 22 g293 10 b293 NMOSWRAP
VG294 g294 0 0.6000000000000000
RB294 b294 0 10
X294 22 g294 11 b294 NMOSWRAP
VG295 g295 0 0.6000000000000000
RB295 b295 0 10
X295 22 g295 11 b295 NMOSWRAP
VG296 g296 0 0.6000000000000000
RB296 b296 0 10
X296 22 g296 11 b296 NMOSWRAP
VG297 g297 0 0.6000000000000000
RB297 b297 0 10
X297 22 g297 12 b297 NMOSWRAP
VG298 g298 0 0.6000000000000000
RB298 b298 0 10
X298 22 g298 12 b298 NMOSWRAP
VG299 g299 0 0.6000000000000000
RB299 b299 0 10
X299 22 g299 12 b299 NMOSWRAP
VG300 g300 0 0.6000000000000000
RB300 b300 0 10
X300 23 g300 3 b300 NMOSWRAP
VG301 g301 0 0.6000000000000000
RB301 b301 0 10
X301 23 g301 3 b301 NMOSWRAP
VG302 g302 0 0.6000000000000000
RB302 b302 0 10
X302 23 g302 3 b302 NMOSWRAP
VG303 g303 0 0.6000000000000000
RB303 b303 0 10
X303 23 g303 4 b303 NMOSWRAP
VG304 g304 0 0.6000000000000000
RB304 b304 0 10
X304 23 g304 4 b304 NMOSWRAP
VG305 g305 0 0.6000000000000000
RB305 b305 0 10
X305 23 g305 4 b305 NMOSWRAP
VG306 g306 0 0.6000000000000000
RB306 b306 0 10
X306 23 g306 5 b306 NMOSWRAP
VG307 g307 0 0.6000000000000000
RB307 b307 0 10
X307 23 g307 5 b307 NMOSWRAP
VG308 g308 0 0.6000000000000000
RB308 b308 0 10
X308 23 g308 5 b308 NMOSWRAP
VG309 g309 0 0.6000000000000000
RB309 b309 0 10
X309 23 g309 6 b309 NMOSWRAP
VG310 g310 0 0.6000000000000000
RB310 b310 0 10
X310 23 g310 6 b310 NMOSWRAP
VG311 g311 0 0.6000000000000000
RB311 b311 0 10
X311 23 g311 6 b311 NMOSWRAP
VG312 g312 0 0.6000000000000000
RB312 b312 0 10
X312 23 g312 7 b312 NMOSWRAP
VG313 g313 0 0.6000000000000000
RB313 b313 0 10
X313 23 g313 7 b313 NMOSWRAP
VG314 g314 0 0.6000000000000000
RB314 b314 0 10
X314 23 g314 7 b314 NMOSWRAP
VG315 g315 0 0.6000000000000000
RB315 b315 0 10
X315 23 g315 8 b315 NMOSWRAP
VG316 g316 0 0.6000000000000000
RB316 b316 0 10
X316 23 g316 8 b316 NMOSWRAP
VG317 g317 0 0.6000000000000000
RB317 b317 0 10
X317 23 g317 8 b317 NMOSWRAP
VG318 g318 0 0.6000000000000000
RB318 b318 0 10
X318 23 g318 9 b318 NMOSWRAP
VG319 g319 0 0.6000000000000000
RB319 b319 0 10
X319 23 g319 9 b319 NMOSWRAP
VG320 g320 0 0.6000000000000000
RB320 b320 0 10
X320 23 g320 9 b320 NMOSWRAP
VG321 g321 0 0.6000000000000000
RB321 b321 0 10
X321 23 g321 10 b321 NMOSWRAP
VG322 g322 0 0.6000000000000000
RB322 b322 0 10
X322 23 g322 10 b322 NMOSWRAP
VG323 g323 0 0.6000000000000000
RB323 b323 0 10
X323 23 g323 10 b323 NMOSWRAP
VG324 g324 0 0.6000000000000000
RB324 b324 0 10
X324 23 g324 11 b324 NMOSWRAP
VG325 g325 0 0.6000000000000000
RB325 b325 0 10
X325 23 g325 11 b325 NMOSWRAP
VG326 g326 0 0.6000000000000000
RB326 b326 0 10
X326 23 g326 11 b326 NMOSWRAP
VG327 g327 0 0.6000000000000000
RB327 b327 0 10
X327 23 g327 12 b327 NMOSWRAP
VG328 g328 0 0.6000000000000000
RB328 b328 0 10
X328 23 g328 12 b328 NMOSWRAP
VG329 g329 0 0.6000000000000000
RB329 b329 0 10
X329 23 g329 12 b329 NMOSWRAP
VG330 g330 0 0.6000000000000000
RB330 b330 0 10
X330 24 g330 3 b330 NMOSWRAP
VG331 g331 0 0.6000000000000000
RB331 b331 0 10
X331 24 g331 3 b331 NMOSWRAP
VG332 g332 0 0.6000000000000000
RB332 b332 0 10
X332 24 g332 3 b332 NMOSWRAP
VG333 g333 0 0.6000000000000000
RB333 b333 0 10
X333 24 g333 4 b333 NMOSWRAP
VG334 g334 0 0.6000000000000000
RB334 b334 0 10
X334 24 g334 4 b334 NMOSWRAP
VG335 g335 0 0.6000000000000000
RB335 b335 0 10
X335 24 g335 4 b335 NMOSWRAP
VG336 g336 0 0.6000000000000000
RB336 b336 0 10
X336 24 g336 5 b336 NMOSWRAP
VG337 g337 0 0.6000000000000000
RB337 b337 0 10
X337 24 g337 5 b337 NMOSWRAP
VG338 g338 0 0.6000000000000000
RB338 b338 0 10
X338 24 g338 5 b338 NMOSWRAP
VG339 g339 0 0.6000000000000000
RB339 b339 0 10
X339 24 g339 6 b339 NMOSWRAP
VG340 g340 0 0.6000000000000000
RB340 b340 0 10
X340 24 g340 6 b340 NMOSWRAP
VG341 g341 0 0.6000000000000000
RB341 b341 0 10
X341 24 g341 6 b341 NMOSWRAP
VG342 g342 0 0.6000000000000000
RB342 b342 0 10
X342 24 g342 7 b342 NMOSWRAP
VG343 g343 0 0.6000000000000000
RB343 b343 0 10
X343 24 g343 7 b343 NMOSWRAP
VG344 g344 0 0.6000000000000000
RB344 b344 0 10
X344 24 g344 7 b344 NMOSWRAP
VG345 g345 0 0.6000000000000000
RB345 b345 0 10
X345 24 g345 8 b345 NMOSWRAP
VG346 g346 0 0.6000000000000000
RB346 b346 0 10
X346 24 g346 8 b346 NMOSWRAP
VG347 g347 0 0.6000000000000000
RB347 b347 0 10
X347 24 g347 8 b347 NMOSWRAP
VG348 g348 0 0.6000000000000000
RB348 b348 0 10
X348 24 g348 9 b348 NMOSWRAP
VG349 g349 0 0.6000000000000000
RB349 b349 0 10
X349 24 g349 9 b349 NMOSWRAP
VG350 g350 0 0.6000000000000000
RB350 b350 0 10
X350 24 g350 9 b350 NMOSWRAP
VG351 g351 0 0.6000000000000000
RB351 b351 0 10
X351 24 g351 10 b351 NMOSWRAP
VG352 g352 0 0.6000000000000000
RB352 b352 0 10
X352 24 g352 10 b352 NMOSWRAP
VG353 g353 0 0.6000000000000000
RB353 b353 0 10
X353 24 g353 10 b353 NMOSWRAP
VG354 g354 0 0.6000000000000000
RB354 b354 0 10
X354 24 g354 11 b354 NMOSWRAP
VG355 g355 0 0.6000000000000000
RB355 b355 0 10
X355 24 g355 11 b355 NMOSWRAP
VG356 g356 0 0.6000000000000000
RB356 b356 0 10
X356 24 g356 11 b356 NMOSWRAP
VG357 g357 0 0.6000000000000000
RB357 b357 0 10
X357 24 g357 12 b357 NMOSWRAP
VG358 g358 0 0.6000000000000000
RB358 b358 0 10
X358 24 g358 12 b358 NMOSWRAP
VG359 g359 0 0.6000000000000000
RB359 b359 0 10
X359 24 g359 12 b359 NMOSWRAP
VG360 g360 0 0.6000000000000000
RB360 b360 0 10
X360 25 g360 3 b360 NMOSWRAP
VG361 g361 0 0.6000000000000000
RB361 b361 0 10
X361 25 g361 3 b361 NMOSWRAP
VG362 g362 0 0.6000000000000000
RB362 b362 0 10
X362 25 g362 3 b362 NMOSWRAP
VG363 g363 0 0.6000000000000000
RB363 b363 0 10
X363 25 g363 4 b363 NMOSWRAP
VG364 g364 0 0.6000000000000000
RB364 b364 0 10
X364 25 g364 4 b364 NMOSWRAP
VG365 g365 0 0.6000000000000000
RB365 b365 0 10
X365 25 g365 4 b365 NMOSWRAP
VG366 g366 0 0.6000000000000000
RB366 b366 0 10
X366 25 g366 5 b366 NMOSWRAP
VG367 g367 0 0.6000000000000000
RB367 b367 0 10
X367 25 g367 5 b367 NMOSWRAP
VG368 g368 0 0.6000000000000000
RB368 b368 0 10
X368 25 g368 5 b368 NMOSWRAP
VG369 g369 0 0.6000000000000000
RB369 b369 0 10
X369 25 g369 6 b369 NMOSWRAP
VG370 g370 0 0.6000000000000000
RB370 b370 0 10
X370 25 g370 6 b370 NMOSWRAP
VG371 g371 0 0.6000000000000000
RB371 b371 0 10
X371 25 g371 6 b371 NMOSWRAP
VG372 g372 0 0.6000000000000000
RB372 b372 0 10
X372 25 g372 7 b372 NMOSWRAP
VG373 g373 0 0.6000000000000000
RB373 b373 0 10
X373 25 g373 7 b373 NMOSWRAP
VG374 g374 0 0.6000000000000000
RB374 b374 0 10
X374 25 g374 7 b374 NMOSWRAP
VG375 g375 0 0.6000000000000000
RB375 b375 0 10
X375 25 g375 8 b375 NMOSWRAP
VG376 g376 0 0.6000000000000000
RB376 b376 0 10
X376 25 g376 8 b376 NMOSWRAP
VG377 g377 0 0.6000000000000000
RB377 b377 0 10
X377 25 g377 8 b377 NMOSWRAP
VG378 g378 0 0.6000000000000000
RB378 b378 0 10
X378 25 g378 9 b378 NMOSWRAP
VG379 g379 0 0.6000000000000000
RB379 b379 0 10
X379 25 g379 9 b379 NMOSWRAP
VG380 g380 0 0.6000000000000000
RB380 b380 0 10
X380 25 g380 9 b380 NMOSWRAP
VG381 g381 0 0.6000000000000000
RB381 b381 0 10
X381 25 g381 10 b381 NMOSWRAP
VG382 g382 0 0.6000000000000000
RB382 b382 0 10
X382 25 g382 10 b382 NMOSWRAP
VG383 g383 0 0.6000000000000000
RB383 b383 0 10
X383 25 g383 10 b383 NMOSWRAP
VG384 g384 0 0.6000000000000000
RB384 b384 0 10
X384 25 g384 11 b384 NMOSWRAP
VG385 g385 0 0.6000000000000000
RB385 b385 0 10
X385 25 g385 11 b385 NMOSWRAP
VG386 g386 0 0.6000000000000000
RB386 b386 0 10
X386 25 g386 11 b386 NMOSWRAP
VG387 g387 0 0.6000000000000000
RB387 b387 0 10
X387 25 g387 12 b387 NMOSWRAP
VG388 g388 0 0.6000000000000000
RB388 b388 0 10
X388 25 g388 12 b388 NMOSWRAP
VG389 g389 0 0.6000000000000000
RB389 b389 0 10
X389 25 g389 12 b389 NMOSWRAP
VG390 g390 0 0.6000000000000000
RB390 b390 0 10
X390 26 g390 3 b390 NMOSWRAP
VG391 g391 0 0.6000000000000000
RB391 b391 0 10
X391 26 g391 3 b391 NMOSWRAP
VG392 g392 0 0.6000000000000000
RB392 b392 0 10
X392 26 g392 3 b392 NMOSWRAP
VG393 g393 0 0.6000000000000000
RB393 b393 0 10
X393 26 g393 4 b393 NMOSWRAP
VG394 g394 0 0.6000000000000000
RB394 b394 0 10
X394 26 g394 4 b394 NMOSWRAP
VG395 g395 0 0.6000000000000000
RB395 b395 0 10
X395 26 g395 4 b395 NMOSWRAP
VG396 g396 0 0.6000000000000000
RB396 b396 0 10
X396 26 g396 5 b396 NMOSWRAP
VG397 g397 0 0.6000000000000000
RB397 b397 0 10
X397 26 g397 5 b397 NMOSWRAP
VG398 g398 0 0.6000000000000000
RB398 b398 0 10
X398 26 g398 5 b398 NMOSWRAP
VG399 g399 0 0.6000000000000000
RB399 b399 0 10
X399 26 g399 6 b399 NMOSWRAP
VG400 g400 0 0.6000000000000000
RB400 b400 0 10
X400 26 g400 6 b400 NMOSWRAP
VG401 g401 0 0.6000000000000000
RB401 b401 0 10
X401 26 g401 6 b401 NMOSWRAP
VG402 g402 0 0.6000000000000000
RB402 b402 0 10
X402 26 g402 7 b402 NMOSWRAP
VG403 g403 0 0.6000000000000000
RB403 b403 0 10
X403 26 g403 7 b403 NMOSWRAP
VG404 g404 0 0.6000000000000000
RB404 b404 0 10
X404 26 g404 7 b404 NMOSWRAP
VG405 g405 0 0.6000000000000000
RB405 b405 0 10
X405 26 g405 8 b405 NMOSWRAP
VG406 g406 0 0.6000000000000000
RB406 b406 0 10
X406 26 g406 8 b406 NMOSWRAP
VG407 g407 0 0.6000000000000000
RB407 b407 0 10
X407 26 g407 8 b407 NMOSWRAP
VG408 g408 0 0.6000000000000000
RB408 b408 0 10
X408 26 g408 9 b408 NMOSWRAP
VG409 g409 0 0.6000000000000000
RB409 b409 0 10
X409 26 g409 9 b409 NMOSWRAP
VG410 g410 0 0.6000000000000000
RB410 b410 0 10
X410 26 g410 9 b410 NMOSWRAP
VG411 g411 0 0.6000000000000000
RB411 b411 0 10
X411 26 g411 10 b411 NMOSWRAP
VG412 g412 0 0.6000000000000000
RB412 b412 0 10
X412 26 g412 10 b412 NMOSWRAP
VG413 g413 0 0.6000000000000000
RB413 b413 0 10
X413 26 g413 10 b413 NMOSWRAP
VG414 g414 0 0.6000000000000000
RB414 b414 0 10
X414 26 g414 11 b414 NMOSWRAP
VG415 g415 0 0.6000000000000000
RB415 b415 0 10
X415 26 g415 11 b415 NMOSWRAP
VG416 g416 0 0.6000000000000000
RB416 b416 0 10
X416 26 g416 11 b416 NMOSWRAP
VG417 g417 0 0.6000000000000000
RB417 b417 0 10
X417 26 g417 12 b417 NMOSWRAP
VG418 g418 0 0.6000000000000000
RB418 b418 0 10
X418 26 g418 12 b418 NMOSWRAP
VG419 g419 0 0.6000000000000000
RB419 b419 0 10
X419 26 g419 12 b419 NMOSWRAP
VG420 g420 0 0.6000000000000000
RB420 b420 0 10
X420 27 g420 3 b420 NMOSWRAP
VG421 g421 0 0.6000000000000000
RB421 b421 0 10
X421 27 g421 3 b421 NMOSWRAP
VG422 g422 0 0.6000000000000000
RB422 b422 0 10
X422 27 g422 3 b422 NMOSWRAP
VG423 g423 0 0.6000000000000000
RB423 b423 0 10
X423 27 g423 4 b423 NMOSWRAP
VG424 g424 0 0.6000000000000000
RB424 b424 0 10
X424 27 g424 4 b424 NMOSWRAP
VG425 g425 0 0.6000000000000000
RB425 b425 0 10
X425 27 g425 4 b425 NMOSWRAP
VG426 g426 0 0.6000000000000000
RB426 b426 0 10
X426 27 g426 5 b426 NMOSWRAP
VG427 g427 0 0.6000000000000000
RB427 b427 0 10
X427 27 g427 5 b427 NMOSWRAP
VG428 g428 0 0.6000000000000000
RB428 b428 0 10
X428 27 g428 5 b428 NMOSWRAP
VG429 g429 0 0.6000000000000000
RB429 b429 0 10
X429 27 g429 6 b429 NMOSWRAP
VG430 g430 0 0.6000000000000000
RB430 b430 0 10
X430 27 g430 6 b430 NMOSWRAP
VG431 g431 0 0.6000000000000000
RB431 b431 0 10
X431 27 g431 6 b431 NMOSWRAP
VG432 g432 0 0.6000000000000000
RB432 b432 0 10
X432 27 g432 7 b432 NMOSWRAP
VG433 g433 0 0.6000000000000000
RB433 b433 0 10
X433 27 g433 7 b433 NMOSWRAP
VG434 g434 0 0.6000000000000000
RB434 b434 0 10
X434 27 g434 7 b434 NMOSWRAP
VG435 g435 0 0.6000000000000000
RB435 b435 0 10
X435 27 g435 8 b435 NMOSWRAP
VG436 g436 0 0.6000000000000000
RB436 b436 0 10
X436 27 g436 8 b436 NMOSWRAP
VG437 g437 0 0.6000000000000000
RB437 b437 0 10
X437 27 g437 8 b437 NMOSWRAP
VG438 g438 0 0.6000000000000000
RB438 b438 0 10
X438 27 g438 9 b438 NMOSWRAP
VG439 g439 0 0.6000000000000000
RB439 b439 0 10
X439 27 g439 9 b439 NMOSWRAP
VG440 g440 0 0.6000000000000000
RB440 b440 0 10
X440 27 g440 9 b440 NMOSWRAP
VG441 g441 0 0.6000000000000000
RB441 b441 0 10
X441 27 g441 10 b441 NMOSWRAP
VG442 g442 0 0.6000000000000000
RB442 b442 0 10
X442 27 g442 10 b442 NMOSWRAP
VG443 g443 0 0.6000000000000000
RB443 b443 0 10
X443 27 g443 10 b443 NMOSWRAP
VG444 g444 0 0.6000000000000000
RB444 b444 0 10
X444 27 g444 11 b444 NMOSWRAP
VG445 g445 0 0.6000000000000000
RB445 b445 0 10
X445 27 g445 11 b445 NMOSWRAP
VG446 g446 0 0.6000000000000000
RB446 b446 0 10
X446 27 g446 11 b446 NMOSWRAP
VG447 g447 0 0.6000000000000000
RB447 b447 0 10
X447 27 g447 12 b447 NMOSWRAP
VG448 g448 0 0.6000000000000000
RB448 b448 0 10
X448 27 g448 12 b448 NMOSWRAP
VG449 g449 0 0.6000000000000000
RB449 b449 0 10
X449 27 g449 12 b449 NMOSWRAP
VG450 g450 0 0.6000000000000000
RB450 b450 0 10
X450 28 g450 3 b450 NMOSWRAP
VG451 g451 0 0.6000000000000000
RB451 b451 0 10
X451 28 g451 3 b451 NMOSWRAP
VG452 g452 0 0.6000000000000000
RB452 b452 0 10
X452 28 g452 3 b452 NMOSWRAP
VG453 g453 0 0.6000000000000000
RB453 b453 0 10
X453 28 g453 4 b453 NMOSWRAP
VG454 g454 0 0.6000000000000000
RB454 b454 0 10
X454 28 g454 4 b454 NMOSWRAP
VG455 g455 0 0.6000000000000000
RB455 b455 0 10
X455 28 g455 4 b455 NMOSWRAP
VG456 g456 0 0.6000000000000000
RB456 b456 0 10
X456 28 g456 5 b456 NMOSWRAP
VG457 g457 0 0.6000000000000000
RB457 b457 0 10
X457 28 g457 5 b457 NMOSWRAP
VG458 g458 0 0.6000000000000000
RB458 b458 0 10
X458 28 g458 5 b458 NMOSWRAP
VG459 g459 0 0.6000000000000000
RB459 b459 0 10
X459 28 g459 6 b459 NMOSWRAP
VG460 g460 0 0.6000000000000000
RB460 b460 0 10
X460 28 g460 6 b460 NMOSWRAP
VG461 g461 0 0.6000000000000000
RB461 b461 0 10
X461 28 g461 6 b461 NMOSWRAP
VG462 g462 0 0.6000000000000000
RB462 b462 0 10
X462 28 g462 7 b462 NMOSWRAP
VG463 g463 0 0.6000000000000000
RB463 b463 0 10
X463 28 g463 7 b463 NMOSWRAP
VG464 g464 0 0.6000000000000000
RB464 b464 0 10
X464 28 g464 7 b464 NMOSWRAP
VG465 g465 0 0.6000000000000000
RB465 b465 0 10
X465 28 g465 8 b465 NMOSWRAP
VG466 g466 0 0.6000000000000000
RB466 b466 0 10
X466 28 g466 8 b466 NMOSWRAP
VG467 g467 0 0.6000000000000000
RB467 b467 0 10
X467 28 g467 8 b467 NMOSWRAP
VG468 g468 0 0.6000000000000000
RB468 b468 0 10
X468 28 g468 9 b468 NMOSWRAP
VG469 g469 0 0.6000000000000000
RB469 b469 0 10
X469 28 g469 9 b469 NMOSWRAP
VG470 g470 0 0.6000000000000000
RB470 b470 0 10
X470 28 g470 9 b470 NMOSWRAP
VG471 g471 0 0.6000000000000000
RB471 b471 0 10
X471 28 g471 10 b471 NMOSWRAP
VG472 g472 0 0.6000000000000000
RB472 b472 0 10
X472 28 g472 10 b472 NMOSWRAP
VG473 g473 0 0.6000000000000000
RB473 b473 0 10
X473 28 g473 10 b473 NMOSWRAP
VG474 g474 0 0.6000000000000000
RB474 b474 0 10
X474 28 g474 11 b474 NMOSWRAP
VG475 g475 0 0.6000000000000000
RB475 b475 0 10
X475 28 g475 11 b475 NMOSWRAP
VG476 g476 0 0.6000000000000000
RB476 b476 0 10
X476 28 g476 11 b476 NMOSWRAP
VG477 g477 0 0.6000000000000000
RB477 b477 0 10
X477 28 g477 12 b477 NMOSWRAP
VG478 g478 0 0.6000000000000000
RB478 b478 0 10
X478 28 g478 12 b478 NMOSWRAP
VG479 g479 0 0.6000000000000000
RB479 b479 0 10
X479 28 g479 12 b479 NMOSWRAP
VG480 g480 0 0.6000000000000000
RB480 b480 0 10
X480 29 g480 3 b480 NMOSWRAP
VG481 g481 0 0.6000000000000000
RB481 b481 0 10
X481 29 g481 3 b481 NMOSWRAP
VG482 g482 0 0.6000000000000000
RB482 b482 0 10
X482 29 g482 3 b482 NMOSWRAP
VG483 g483 0 0.6000000000000000
RB483 b483 0 10
X483 29 g483 4 b483 NMOSWRAP
VG484 g484 0 0.6000000000000000
RB484 b484 0 10
X484 29 g484 4 b484 NMOSWRAP
VG485 g485 0 0.6000000000000000
RB485 b485 0 10
X485 29 g485 4 b485 NMOSWRAP
VG486 g486 0 0.6000000000000000
RB486 b486 0 10
X486 29 g486 5 b486 NMOSWRAP
VG487 g487 0 0.6000000000000000
RB487 b487 0 10
X487 29 g487 5 b487 NMOSWRAP
VG488 g488 0 0.6000000000000000
RB488 b488 0 10
X488 29 g488 5 b488 NMOSWRAP
VG489 g489 0 0.6000000000000000
RB489 b489 0 10
X489 29 g489 6 b489 NMOSWRAP
VG490 g490 0 0.6000000000000000
RB490 b490 0 10
X490 29 g490 6 b490 NMOSWRAP
VG491 g491 0 0.6000000000000000
RB491 b491 0 10
X491 29 g491 6 b491 NMOSWRAP
VG492 g492 0 0.6000000000000000
RB492 b492 0 10
X492 29 g492 7 b492 NMOSWRAP
VG493 g493 0 0.6000000000000000
RB493 b493 0 10
X493 29 g493 7 b493 NMOSWRAP
VG494 g494 0 0.6000000000000000
RB494 b494 0 10
X494 29 g494 7 b494 NMOSWRAP
VG495 g495 0 0.6000000000000000
RB495 b495 0 10
X495 29 g495 8 b495 NMOSWRAP
VG496 g496 0 0.6000000000000000
RB496 b496 0 10
X496 29 g496 8 b496 NMOSWRAP
VG497 g497 0 0.6000000000000000
RB497 b497 0 10
X497 29 g497 8 b497 NMOSWRAP
VG498 g498 0 0.6000000000000000
RB498 b498 0 10
X498 29 g498 9 b498 NMOSWRAP
VG499 g499 0 0.6000000000000000
RB499 b499 0 10
X499 29 g499 9 b499 NMOSWRAP
VG500 g500 0 0.6000000000000000
RB500 b500 0 10
X500 29 g500 9 b500 NMOSWRAP
VG501 g501 0 0.6000000000000000
RB501 b501 0 10
X501 29 g501 10 b501 NMOSWRAP
VG502 g502 0 0.6000000000000000
RB502 b502 0 10
X502 29 g502 10 b502 NMOSWRAP
VG503 g503 0 0.6000000000000000
RB503 b503 0 10
X503 29 g503 10 b503 NMOSWRAP
VG504 g504 0 0.6000000000000000
RB504 b504 0 10
X504 29 g504 11 b504 NMOSWRAP
VG505 g505 0 0.6000000000000000
RB505 b505 0 10
X505 29 g505 11 b505 NMOSWRAP
VG506 g506 0 0.6000000000000000
RB506 b506 0 10
X506 29 g506 11 b506 NMOSWRAP
VG507 g507 0 0.6000000000000000
RB507 b507 0 10
X507 29 g507 12 b507 NMOSWRAP
VG508 g508 0 0.6000000000000000
RB508 b508 0 10
X508 29 g508 12 b508 NMOSWRAP
VG509 g509 0 0.6000000000000000
RB509 b509 0 10
X509 29 g509 12 b509 NMOSWRAP
VG510 g510 0 0.6000000000000000
RB510 b510 0 10
X510 30 g510 3 b510 NMOSWRAP
VG511 g511 0 0.6000000000000000
RB511 b511 0 10
X511 30 g511 3 b511 NMOSWRAP
VG512 g512 0 0.6000000000000000
RB512 b512 0 10
X512 30 g512 3 b512 NMOSWRAP
VG513 g513 0 0.6000000000000000
RB513 b513 0 10
X513 30 g513 4 b513 NMOSWRAP
VG514 g514 0 0.6000000000000000
RB514 b514 0 10
X514 30 g514 4 b514 NMOSWRAP
VG515 g515 0 0.6000000000000000
RB515 b515 0 10
X515 30 g515 4 b515 NMOSWRAP
VG516 g516 0 0.6000000000000000
RB516 b516 0 10
X516 30 g516 5 b516 NMOSWRAP
VG517 g517 0 0.6000000000000000
RB517 b517 0 10
X517 30 g517 5 b517 NMOSWRAP
VG518 g518 0 0.6000000000000000
RB518 b518 0 10
X518 30 g518 5 b518 NMOSWRAP
VG519 g519 0 0.6000000000000000
RB519 b519 0 10
X519 30 g519 6 b519 NMOSWRAP
VG520 g520 0 0.6000000000000000
RB520 b520 0 10
X520 30 g520 6 b520 NMOSWRAP
VG521 g521 0 0.6000000000000000
RB521 b521 0 10
X521 30 g521 6 b521 NMOSWRAP
VG522 g522 0 0.6000000000000000
RB522 b522 0 10
X522 30 g522 7 b522 NMOSWRAP
VG523 g523 0 0.6000000000000000
RB523 b523 0 10
X523 30 g523 7 b523 NMOSWRAP
VG524 g524 0 0.6000000000000000
RB524 b524 0 10
X524 30 g524 7 b524 NMOSWRAP
VG525 g525 0 0.6000000000000000
RB525 b525 0 10
X525 30 g525 8 b525 NMOSWRAP
VG526 g526 0 0.6000000000000000
RB526 b526 0 10
X526 30 g526 8 b526 NMOSWRAP
VG527 g527 0 0.6000000000000000
RB527 b527 0 10
X527 30 g527 8 b527 NMOSWRAP
VG528 g528 0 0.6000000000000000
RB528 b528 0 10
X528 30 g528 9 b528 NMOSWRAP
VG529 g529 0 0.6000000000000000
RB529 b529 0 10
X529 30 g529 9 b529 NMOSWRAP
VG530 g530 0 0.6000000000000000
RB530 b530 0 10
X530 30 g530 9 b530 NMOSWRAP
VG531 g531 0 0.6000000000000000
RB531 b531 0 10
X531 30 g531 10 b531 NMOSWRAP
VG532 g532 0 0.6000000000000000
RB532 b532 0 10
X532 30 g532 10 b532 NMOSWRAP
VG533 g533 0 0.6000000000000000
RB533 b533 0 10
X533 30 g533 10 b533 NMOSWRAP
VG534 g534 0 0.6000000000000000
RB534 b534 0 10
X534 30 g534 11 b534 NMOSWRAP
VG535 g535 0 0.6000000000000000
RB535 b535 0 10
X535 30 g535 11 b535 NMOSWRAP
VG536 g536 0 0.6000000000000000
RB536 b536 0 10
X536 30 g536 11 b536 NMOSWRAP
VG537 g537 0 0.6000000000000000
RB537 b537 0 10
X537 30 g537 12 b537 NMOSWRAP
VG538 g538 0 0.6000000000000000
RB538 b538 0 10
X538 30 g538 12 b538 NMOSWRAP
VG539 g539 0 0.6000000000000000
RB539 b539 0 10
X539 30 g539 12 b539 NMOSWRAP
VG540 g540 0 0.6000000000000000
RB540 b540 0 10
X540 31 g540 3 b540 NMOSWRAP
VG541 g541 0 0.6000000000000000
RB541 b541 0 10
X541 31 g541 3 b541 NMOSWRAP
VG542 g542 0 0.6000000000000000
RB542 b542 0 10
X542 31 g542 3 b542 NMOSWRAP
VG543 g543 0 0.6000000000000000
RB543 b543 0 10
X543 31 g543 4 b543 NMOSWRAP
VG544 g544 0 0.6000000000000000
RB544 b544 0 10
X544 31 g544 4 b544 NMOSWRAP
VG545 g545 0 0.6000000000000000
RB545 b545 0 10
X545 31 g545 4 b545 NMOSWRAP
VG546 g546 0 0.6000000000000000
RB546 b546 0 10
X546 31 g546 5 b546 NMOSWRAP
VG547 g547 0 0.6000000000000000
RB547 b547 0 10
X547 31 g547 5 b547 NMOSWRAP
VG548 g548 0 0.6000000000000000
RB548 b548 0 10
X548 31 g548 5 b548 NMOSWRAP
VG549 g549 0 0.6000000000000000
RB549 b549 0 10
X549 31 g549 6 b549 NMOSWRAP
VG550 g550 0 0.6000000000000000
RB550 b550 0 10
X550 31 g550 6 b550 NMOSWRAP
VG551 g551 0 0.6000000000000000
RB551 b551 0 10
X551 31 g551 6 b551 NMOSWRAP
VG552 g552 0 0.6000000000000000
RB552 b552 0 10
X552 31 g552 7 b552 NMOSWRAP
VG553 g553 0 0.6000000000000000
RB553 b553 0 10
X553 31 g553 7 b553 NMOSWRAP
VG554 g554 0 0.6000000000000000
RB554 b554 0 10
X554 31 g554 7 b554 NMOSWRAP
VG555 g555 0 0.6000000000000000
RB555 b555 0 10
X555 31 g555 8 b555 NMOSWRAP
VG556 g556 0 0.6000000000000000
RB556 b556 0 10
X556 31 g556 8 b556 NMOSWRAP
VG557 g557 0 0.6000000000000000
RB557 b557 0 10
X557 31 g557 8 b557 NMOSWRAP
VG558 g558 0 0.6000000000000000
RB558 b558 0 10
X558 31 g558 9 b558 NMOSWRAP
VG559 g559 0 0.6000000000000000
RB559 b559 0 10
X559 31 g559 9 b559 NMOSWRAP
VG560 g560 0 0.6000000000000000
RB560 b560 0 10
X560 31 g560 9 b560 NMOSWRAP
VG561 g561 0 0.6000000000000000
RB561 b561 0 10
X561 31 g561 10 b561 NMOSWRAP
VG562 g562 0 0.6000000000000000
RB562 b562 0 10
X562 31 g562 10 b562 NMOSWRAP
VG563 g563 0 0.6000000000000000
RB563 b563 0 10
X563 31 g563 10 b563 NMOSWRAP
VG564 g564 0 0.6000000000000000
RB564 b564 0 10
X564 31 g564 11 b564 NMOSWRAP
VG565 g565 0 0.6000000000000000
RB565 b565 0 10
X565 31 g565 11 b565 NMOSWRAP
VG566 g566 0 0.6000000000000000
RB566 b566 0 10
X566 31 g566 11 b566 NMOSWRAP
VG567 g567 0 0.6000000000000000
RB567 b567 0 10
X567 31 g567 12 b567 NMOSWRAP
VG568 g568 0 0.6000000000000000
RB568 b568 0 10
X568 31 g568 12 b568 NMOSWRAP
VG569 g569 0 0.6000000000000000
RB569 b569 0 10
X569 31 g569 12 b569 NMOSWRAP
VG570 g570 0 0.6000000000000000
RB570 b570 0 10
X570 32 g570 3 b570 NMOSWRAP
VG571 g571 0 0.6000000000000000
RB571 b571 0 10
X571 32 g571 3 b571 NMOSWRAP
VG572 g572 0 0.6000000000000000
RB572 b572 0 10
X572 32 g572 3 b572 NMOSWRAP
VG573 g573 0 0.6000000000000000
RB573 b573 0 10
X573 32 g573 4 b573 NMOSWRAP
VG574 g574 0 0.6000000000000000
RB574 b574 0 10
X574 32 g574 4 b574 NMOSWRAP
VG575 g575 0 0.6000000000000000
RB575 b575 0 10
X575 32 g575 4 b575 NMOSWRAP
VG576 g576 0 0.6000000000000000
RB576 b576 0 10
X576 32 g576 5 b576 NMOSWRAP
VG577 g577 0 0.6000000000000000
RB577 b577 0 10
X577 32 g577 5 b577 NMOSWRAP
VG578 g578 0 0.6000000000000000
RB578 b578 0 10
X578 32 g578 5 b578 NMOSWRAP
VG579 g579 0 0.6000000000000000
RB579 b579 0 10
X579 32 g579 6 b579 NMOSWRAP
VG580 g580 0 0.6000000000000000
RB580 b580 0 10
X580 32 g580 6 b580 NMOSWRAP
VG581 g581 0 0.6000000000000000
RB581 b581 0 10
X581 32 g581 6 b581 NMOSWRAP
VG582 g582 0 0.6000000000000000
RB582 b582 0 10
X582 32 g582 7 b582 NMOSWRAP
VG583 g583 0 0.6000000000000000
RB583 b583 0 10
X583 32 g583 7 b583 NMOSWRAP
VG584 g584 0 0.6000000000000000
RB584 b584 0 10
X584 32 g584 7 b584 NMOSWRAP
VG585 g585 0 0.6000000000000000
RB585 b585 0 10
X585 32 g585 8 b585 NMOSWRAP
VG586 g586 0 0.6000000000000000
RB586 b586 0 10
X586 32 g586 8 b586 NMOSWRAP
VG587 g587 0 0.6000000000000000
RB587 b587 0 10
X587 32 g587 8 b587 NMOSWRAP
VG588 g588 0 0.6000000000000000
RB588 b588 0 10
X588 32 g588 9 b588 NMOSWRAP
VG589 g589 0 0.6000000000000000
RB589 b589 0 10
X589 32 g589 9 b589 NMOSWRAP
VG590 g590 0 0.6000000000000000
RB590 b590 0 10
X590 32 g590 9 b590 NMOSWRAP
VG591 g591 0 0.6000000000000000
RB591 b591 0 10
X591 32 g591 10 b591 NMOSWRAP
VG592 g592 0 0.6000000000000000
RB592 b592 0 10
X592 32 g592 10 b592 NMOSWRAP
VG593 g593 0 0.6000000000000000
RB593 b593 0 10
X593 32 g593 10 b593 NMOSWRAP
VG594 g594 0 0.6000000000000000
RB594 b594 0 10
X594 32 g594 11 b594 NMOSWRAP
VG595 g595 0 0.6000000000000000
RB595 b595 0 10
X595 32 g595 11 b595 NMOSWRAP
VG596 g596 0 0.6000000000000000
RB596 b596 0 10
X596 32 g596 11 b596 NMOSWRAP
VG597 g597 0 0.6000000000000000
RB597 b597 0 10
X597 32 g597 12 b597 NMOSWRAP
VG598 g598 0 0.6000000000000000
RB598 b598 0 10
X598 32 g598 12 b598 NMOSWRAP
VG599 g599 0 0.6000000000000000
RB599 b599 0 10
X599 32 g599 12 b599 NMOSWRAP
VG600 g600 0 0.6000000000000000
RB600 b600 0 10
X600 33 g600 3 b600 NMOSWRAP
VG601 g601 0 0.6000000000000000
RB601 b601 0 10
X601 33 g601 3 b601 NMOSWRAP
VG602 g602 0 0.6000000000000000
RB602 b602 0 10
X602 33 g602 3 b602 NMOSWRAP
VG603 g603 0 0.6000000000000000
RB603 b603 0 10
X603 33 g603 4 b603 NMOSWRAP
VG604 g604 0 0.6000000000000000
RB604 b604 0 10
X604 33 g604 4 b604 NMOSWRAP
VG605 g605 0 0.6000000000000000
RB605 b605 0 10
X605 33 g605 4 b605 NMOSWRAP
VG606 g606 0 0.6000000000000000
RB606 b606 0 10
X606 33 g606 5 b606 NMOSWRAP
VG607 g607 0 0.6000000000000000
RB607 b607 0 10
X607 33 g607 5 b607 NMOSWRAP
VG608 g608 0 0.6000000000000000
RB608 b608 0 10
X608 33 g608 5 b608 NMOSWRAP
VG609 g609 0 0.6000000000000000
RB609 b609 0 10
X609 33 g609 6 b609 NMOSWRAP
VG610 g610 0 0.6000000000000000
RB610 b610 0 10
X610 33 g610 6 b610 NMOSWRAP
VG611 g611 0 0.6000000000000000
RB611 b611 0 10
X611 33 g611 6 b611 NMOSWRAP
VG612 g612 0 0.6000000000000000
RB612 b612 0 10
X612 33 g612 7 b612 NMOSWRAP
VG613 g613 0 0.6000000000000000
RB613 b613 0 10
X613 33 g613 7 b613 NMOSWRAP
VG614 g614 0 0.6000000000000000
RB614 b614 0 10
X614 33 g614 7 b614 NMOSWRAP
VG615 g615 0 0.6000000000000000
RB615 b615 0 10
X615 33 g615 8 b615 NMOSWRAP
VG616 g616 0 0.6000000000000000
RB616 b616 0 10
X616 33 g616 8 b616 NMOSWRAP
VG617 g617 0 0.6000000000000000
RB617 b617 0 10
X617 33 g617 8 b617 NMOSWRAP
VG618 g618 0 0.6000000000000000
RB618 b618 0 10
X618 33 g618 9 b618 NMOSWRAP
VG619 g619 0 0.6000000000000000
RB619 b619 0 10
X619 33 g619 9 b619 NMOSWRAP
VG620 g620 0 0.6000000000000000
RB620 b620 0 10
X620 33 g620 9 b620 NMOSWRAP
VG621 g621 0 0.6000000000000000
RB621 b621 0 10
X621 33 g621 10 b621 NMOSWRAP
VG622 g622 0 0.6000000000000000
RB622 b622 0 10
X622 33 g622 10 b622 NMOSWRAP
VG623 g623 0 0.6000000000000000
RB623 b623 0 10
X623 33 g623 10 b623 NMOSWRAP
VG624 g624 0 0.6000000000000000
RB624 b624 0 10
X624 33 g624 11 b624 NMOSWRAP
VG625 g625 0 0.6000000000000000
RB625 b625 0 10
X625 33 g625 11 b625 NMOSWRAP
VG626 g626 0 0.6000000000000000
RB626 b626 0 10
X626 33 g626 11 b626 NMOSWRAP
VG627 g627 0 0.6000000000000000
RB627 b627 0 10
X627 33 g627 12 b627 NMOSWRAP
VG628 g628 0 0.6000000000000000
RB628 b628 0 10
X628 33 g628 12 b628 NMOSWRAP
VG629 g629 0 0.6000000000000000
RB629 b629 0 10
X629 33 g629 12 b629 NMOSWRAP
VG630 g630 0 0.6000000000000000
RB630 b630 0 10
X630 34 g630 3 b630 NMOSWRAP
VG631 g631 0 0.6000000000000000
RB631 b631 0 10
X631 34 g631 3 b631 NMOSWRAP
VG632 g632 0 0.6000000000000000
RB632 b632 0 10
X632 34 g632 3 b632 NMOSWRAP
VG633 g633 0 0.6000000000000000
RB633 b633 0 10
X633 34 g633 4 b633 NMOSWRAP
VG634 g634 0 0.6000000000000000
RB634 b634 0 10
X634 34 g634 4 b634 NMOSWRAP
VG635 g635 0 0.6000000000000000
RB635 b635 0 10
X635 34 g635 4 b635 NMOSWRAP
VG636 g636 0 0.6000000000000000
RB636 b636 0 10
X636 34 g636 5 b636 NMOSWRAP
VG637 g637 0 0.6000000000000000
RB637 b637 0 10
X637 34 g637 5 b637 NMOSWRAP
VG638 g638 0 0.6000000000000000
RB638 b638 0 10
X638 34 g638 5 b638 NMOSWRAP
VG639 g639 0 0.6000000000000000
RB639 b639 0 10
X639 34 g639 6 b639 NMOSWRAP
VG640 g640 0 0.6000000000000000
RB640 b640 0 10
X640 34 g640 6 b640 NMOSWRAP
VG641 g641 0 0.6000000000000000
RB641 b641 0 10
X641 34 g641 6 b641 NMOSWRAP
VG642 g642 0 0.6000000000000000
RB642 b642 0 10
X642 34 g642 7 b642 NMOSWRAP
VG643 g643 0 0.6000000000000000
RB643 b643 0 10
X643 34 g643 7 b643 NMOSWRAP
VG644 g644 0 0.6000000000000000
RB644 b644 0 10
X644 34 g644 7 b644 NMOSWRAP
VG645 g645 0 0.6000000000000000
RB645 b645 0 10
X645 34 g645 8 b645 NMOSWRAP
VG646 g646 0 0.6000000000000000
RB646 b646 0 10
X646 34 g646 8 b646 NMOSWRAP
VG647 g647 0 0.6000000000000000
RB647 b647 0 10
X647 34 g647 8 b647 NMOSWRAP
VG648 g648 0 0.6000000000000000
RB648 b648 0 10
X648 34 g648 9 b648 NMOSWRAP
VG649 g649 0 0.6000000000000000
RB649 b649 0 10
X649 34 g649 9 b649 NMOSWRAP
VG650 g650 0 0.6000000000000000
RB650 b650 0 10
X650 34 g650 9 b650 NMOSWRAP
VG651 g651 0 0.6000000000000000
RB651 b651 0 10
X651 34 g651 10 b651 NMOSWRAP
VG652 g652 0 0.6000000000000000
RB652 b652 0 10
X652 34 g652 10 b652 NMOSWRAP
VG653 g653 0 0.6000000000000000
RB653 b653 0 10
X653 34 g653 10 b653 NMOSWRAP
VG654 g654 0 0.6000000000000000
RB654 b654 0 10
X654 34 g654 11 b654 NMOSWRAP
VG655 g655 0 0.6000000000000000
RB655 b655 0 10
X655 34 g655 11 b655 NMOSWRAP
VG656 g656 0 0.6000000000000000
RB656 b656 0 10
X656 34 g656 11 b656 NMOSWRAP
VG657 g657 0 0.6000000000000000
RB657 b657 0 10
X657 34 g657 12 b657 NMOSWRAP
VG658 g658 0 0.6000000000000000
RB658 b658 0 10
X658 34 g658 12 b658 NMOSWRAP
VG659 g659 0 0.6000000000000000
RB659 b659 0 10
X659 34 g659 12 b659 NMOSWRAP
VG660 g660 0 0.6000000000000000
RB660 b660 0 10
X660 35 g660 3 b660 NMOSWRAP
VG661 g661 0 0.6000000000000000
RB661 b661 0 10
X661 35 g661 3 b661 NMOSWRAP
VG662 g662 0 0.6000000000000000
RB662 b662 0 10
X662 35 g662 3 b662 NMOSWRAP
VG663 g663 0 0.6000000000000000
RB663 b663 0 10
X663 35 g663 4 b663 NMOSWRAP
VG664 g664 0 0.6000000000000000
RB664 b664 0 10
X664 35 g664 4 b664 NMOSWRAP
VG665 g665 0 0.6000000000000000
RB665 b665 0 10
X665 35 g665 4 b665 NMOSWRAP
VG666 g666 0 0.6000000000000000
RB666 b666 0 10
X666 35 g666 5 b666 NMOSWRAP
VG667 g667 0 0.6000000000000000
RB667 b667 0 10
X667 35 g667 5 b667 NMOSWRAP
VG668 g668 0 0.6000000000000000
RB668 b668 0 10
X668 35 g668 5 b668 NMOSWRAP
VG669 g669 0 0.6000000000000000
RB669 b669 0 10
X669 35 g669 6 b669 NMOSWRAP
VG670 g670 0 0.6000000000000000
RB670 b670 0 10
X670 35 g670 6 b670 NMOSWRAP
VG671 g671 0 0.6000000000000000
RB671 b671 0 10
X671 35 g671 6 b671 NMOSWRAP
VG672 g672 0 0.6000000000000000
RB672 b672 0 10
X672 35 g672 7 b672 NMOSWRAP
VG673 g673 0 0.6000000000000000
RB673 b673 0 10
X673 35 g673 7 b673 NMOSWRAP
VG674 g674 0 0.6000000000000000
RB674 b674 0 10
X674 35 g674 7 b674 NMOSWRAP
VG675 g675 0 0.6000000000000000
RB675 b675 0 10
X675 35 g675 8 b675 NMOSWRAP
VG676 g676 0 0.6000000000000000
RB676 b676 0 10
X676 35 g676 8 b676 NMOSWRAP
VG677 g677 0 0.6000000000000000
RB677 b677 0 10
X677 35 g677 8 b677 NMOSWRAP
VG678 g678 0 0.6000000000000000
RB678 b678 0 10
X678 35 g678 9 b678 NMOSWRAP
VG679 g679 0 0.6000000000000000
RB679 b679 0 10
X679 35 g679 9 b679 NMOSWRAP
VG680 g680 0 0.6000000000000000
RB680 b680 0 10
X680 35 g680 9 b680 NMOSWRAP
VG681 g681 0 0.6000000000000000
RB681 b681 0 10
X681 35 g681 10 b681 NMOSWRAP
VG682 g682 0 0.6000000000000000
RB682 b682 0 10
X682 35 g682 10 b682 NMOSWRAP
VG683 g683 0 0.6000000000000000
RB683 b683 0 10
X683 35 g683 10 b683 NMOSWRAP
VG684 g684 0 0.6000000000000000
RB684 b684 0 10
X684 35 g684 11 b684 NMOSWRAP
VG685 g685 0 0.6000000000000000
RB685 b685 0 10
X685 35 g685 11 b685 NMOSWRAP
VG686 g686 0 0.6000000000000000
RB686 b686 0 10
X686 35 g686 11 b686 NMOSWRAP
VG687 g687 0 0.6000000000000000
RB687 b687 0 10
X687 35 g687 12 b687 NMOSWRAP
VG688 g688 0 0.6000000000000000
RB688 b688 0 10
X688 35 g688 12 b688 NMOSWRAP
VG689 g689 0 0.6000000000000000
RB689 b689 0 10
X689 35 g689 12 b689 NMOSWRAP
VG690 g690 0 0.6000000000000000
RB690 b690 0 10
X690 36 g690 3 b690 NMOSWRAP
VG691 g691 0 0.6000000000000000
RB691 b691 0 10
X691 36 g691 3 b691 NMOSWRAP
VG692 g692 0 0.6000000000000000
RB692 b692 0 10
X692 36 g692 3 b692 NMOSWRAP
VG693 g693 0 0.6000000000000000
RB693 b693 0 10
X693 36 g693 4 b693 NMOSWRAP
VG694 g694 0 0.6000000000000000
RB694 b694 0 10
X694 36 g694 4 b694 NMOSWRAP
VG695 g695 0 0.6000000000000000
RB695 b695 0 10
X695 36 g695 4 b695 NMOSWRAP
VG696 g696 0 0.6000000000000000
RB696 b696 0 10
X696 36 g696 5 b696 NMOSWRAP
VG697 g697 0 0.6000000000000000
RB697 b697 0 10
X697 36 g697 5 b697 NMOSWRAP
VG698 g698 0 0.6000000000000000
RB698 b698 0 10
X698 36 g698 5 b698 NMOSWRAP
VG699 g699 0 0.6000000000000000
RB699 b699 0 10
X699 36 g699 6 b699 NMOSWRAP
VG700 g700 0 0.6000000000000000
RB700 b700 0 10
X700 36 g700 6 b700 NMOSWRAP
VG701 g701 0 0.6000000000000000
RB701 b701 0 10
X701 36 g701 6 b701 NMOSWRAP
VG702 g702 0 0.6000000000000000
RB702 b702 0 10
X702 36 g702 7 b702 NMOSWRAP
VG703 g703 0 0.6000000000000000
RB703 b703 0 10
X703 36 g703 7 b703 NMOSWRAP
VG704 g704 0 0.6000000000000000
RB704 b704 0 10
X704 36 g704 7 b704 NMOSWRAP
VG705 g705 0 0.6000000000000000
RB705 b705 0 10
X705 36 g705 8 b705 NMOSWRAP
VG706 g706 0 0.6000000000000000
RB706 b706 0 10
X706 36 g706 8 b706 NMOSWRAP
VG707 g707 0 0.6000000000000000
RB707 b707 0 10
X707 36 g707 8 b707 NMOSWRAP
VG708 g708 0 0.6000000000000000
RB708 b708 0 10
X708 36 g708 9 b708 NMOSWRAP
VG709 g709 0 0.6000000000000000
RB709 b709 0 10
X709 36 g709 9 b709 NMOSWRAP
VG710 g710 0 0.6000000000000000
RB710 b710 0 10
X710 36 g710 9 b710 NMOSWRAP
VG711 g711 0 0.6000000000000000
RB711 b711 0 10
X711 36 g711 10 b711 NMOSWRAP
VG712 g712 0 0.6000000000000000
RB712 b712 0 10
X712 36 g712 10 b712 NMOSWRAP
VG713 g713 0 0.6000000000000000
RB713 b713 0 10
X713 36 g713 10 b713 NMOSWRAP
VG714 g714 0 0.6000000000000000
RB714 b714 0 10
X714 36 g714 11 b714 NMOSWRAP
VG715 g715 0 0.6000000000000000
RB715 b715 0 10
X715 36 g715 11 b715 NMOSWRAP
VG716 g716 0 0.6000000000000000
RB716 b716 0 10
X716 36 g716 11 b716 NMOSWRAP
VG717 g717 0 0.6000000000000000
RB717 b717 0 10
X717 36 g717 12 b717 NMOSWRAP
VG718 g718 0 0.6000000000000000
RB718 b718 0 10
X718 36 g718 12 b718 NMOSWRAP
VG719 g719 0 0.6000000000000000
RB719 b719 0 10
X719 36 g719 12 b719 NMOSWRAP
VG720 g720 0 0.6000000000000000
RB720 b720 0 10
X720 37 g720 3 b720 NMOSWRAP
VG721 g721 0 0.6000000000000000
RB721 b721 0 10
X721 37 g721 3 b721 NMOSWRAP
VG722 g722 0 0.6000000000000000
RB722 b722 0 10
X722 37 g722 3 b722 NMOSWRAP
VG723 g723 0 0.6000000000000000
RB723 b723 0 10
X723 37 g723 4 b723 NMOSWRAP
VG724 g724 0 0.6000000000000000
RB724 b724 0 10
X724 37 g724 4 b724 NMOSWRAP
VG725 g725 0 0.6000000000000000
RB725 b725 0 10
X725 37 g725 4 b725 NMOSWRAP
VG726 g726 0 0.6000000000000000
RB726 b726 0 10
X726 37 g726 5 b726 NMOSWRAP
VG727 g727 0 0.6000000000000000
RB727 b727 0 10
X727 37 g727 5 b727 NMOSWRAP
VG728 g728 0 0.6000000000000000
RB728 b728 0 10
X728 37 g728 5 b728 NMOSWRAP
VG729 g729 0 0.6000000000000000
RB729 b729 0 10
X729 37 g729 6 b729 NMOSWRAP
VG730 g730 0 0.6000000000000000
RB730 b730 0 10
X730 37 g730 6 b730 NMOSWRAP
VG731 g731 0 0.6000000000000000
RB731 b731 0 10
X731 37 g731 6 b731 NMOSWRAP
VG732 g732 0 0.6000000000000000
RB732 b732 0 10
X732 37 g732 7 b732 NMOSWRAP
VG733 g733 0 0.6000000000000000
RB733 b733 0 10
X733 37 g733 7 b733 NMOSWRAP
VG734 g734 0 0.6000000000000000
RB734 b734 0 10
X734 37 g734 7 b734 NMOSWRAP
VG735 g735 0 0.6000000000000000
RB735 b735 0 10
X735 37 g735 8 b735 NMOSWRAP
VG736 g736 0 0.6000000000000000
RB736 b736 0 10
X736 37 g736 8 b736 NMOSWRAP
VG737 g737 0 0.6000000000000000
RB737 b737 0 10
X737 37 g737 8 b737 NMOSWRAP
VG738 g738 0 0.6000000000000000
RB738 b738 0 10
X738 37 g738 9 b738 NMOSWRAP
VG739 g739 0 0.6000000000000000
RB739 b739 0 10
X739 37 g739 9 b739 NMOSWRAP
VG740 g740 0 0.6000000000000000
RB740 b740 0 10
X740 37 g740 9 b740 NMOSWRAP
VG741 g741 0 0.6000000000000000
RB741 b741 0 10
X741 37 g741 10 b741 NMOSWRAP
VG742 g742 0 0.6000000000000000
RB742 b742 0 10
X742 37 g742 10 b742 NMOSWRAP
VG743 g743 0 0.6000000000000000
RB743 b743 0 10
X743 37 g743 10 b743 NMOSWRAP
VG744 g744 0 0.6000000000000000
RB744 b744 0 10
X744 37 g744 11 b744 NMOSWRAP
VG745 g745 0 0.6000000000000000
RB745 b745 0 10
X745 37 g745 11 b745 NMOSWRAP
VG746 g746 0 0.6000000000000000
RB746 b746 0 10
X746 37 g746 11 b746 NMOSWRAP
VG747 g747 0 0.6000000000000000
RB747 b747 0 10
X747 37 g747 12 b747 NMOSWRAP
VG748 g748 0 0.6000000000000000
RB748 b748 0 10
X748 37 g748 12 b748 NMOSWRAP
VG749 g749 0 0.6000000000000000
RB749 b749 0 10
X749 37 g749 12 b749 NMOSWRAP
VG750 g750 0 0.6000000000000000
RB750 b750 0 10
X750 38 g750 3 b750 NMOSWRAP
VG751 g751 0 0.6000000000000000
RB751 b751 0 10
X751 38 g751 3 b751 NMOSWRAP
VG752 g752 0 0.6000000000000000
RB752 b752 0 10
X752 38 g752 3 b752 NMOSWRAP
VG753 g753 0 0.6000000000000000
RB753 b753 0 10
X753 38 g753 4 b753 NMOSWRAP
VG754 g754 0 0.6000000000000000
RB754 b754 0 10
X754 38 g754 4 b754 NMOSWRAP
VG755 g755 0 0.6000000000000000
RB755 b755 0 10
X755 38 g755 4 b755 NMOSWRAP
VG756 g756 0 0.6000000000000000
RB756 b756 0 10
X756 38 g756 5 b756 NMOSWRAP
VG757 g757 0 0.6000000000000000
RB757 b757 0 10
X757 38 g757 5 b757 NMOSWRAP
VG758 g758 0 0.6000000000000000
RB758 b758 0 10
X758 38 g758 5 b758 NMOSWRAP
VG759 g759 0 0.6000000000000000
RB759 b759 0 10
X759 38 g759 6 b759 NMOSWRAP
VG760 g760 0 0.6000000000000000
RB760 b760 0 10
X760 38 g760 6 b760 NMOSWRAP
VG761 g761 0 0.6000000000000000
RB761 b761 0 10
X761 38 g761 6 b761 NMOSWRAP
VG762 g762 0 0.6000000000000000
RB762 b762 0 10
X762 38 g762 7 b762 NMOSWRAP
VG763 g763 0 0.6000000000000000
RB763 b763 0 10
X763 38 g763 7 b763 NMOSWRAP
VG764 g764 0 0.6000000000000000
RB764 b764 0 10
X764 38 g764 7 b764 NMOSWRAP
VG765 g765 0 0.6000000000000000
RB765 b765 0 10
X765 38 g765 8 b765 NMOSWRAP
VG766 g766 0 0.6000000000000000
RB766 b766 0 10
X766 38 g766 8 b766 NMOSWRAP
VG767 g767 0 0.6000000000000000
RB767 b767 0 10
X767 38 g767 8 b767 NMOSWRAP
VG768 g768 0 0.6000000000000000
RB768 b768 0 10
X768 38 g768 9 b768 NMOSWRAP
VG769 g769 0 0.6000000000000000
RB769 b769 0 10
X769 38 g769 9 b769 NMOSWRAP
VG770 g770 0 0.6000000000000000
RB770 b770 0 10
X770 38 g770 9 b770 NMOSWRAP
VG771 g771 0 0.6000000000000000
RB771 b771 0 10
X771 38 g771 10 b771 NMOSWRAP
VG772 g772 0 0.6000000000000000
RB772 b772 0 10
X772 38 g772 10 b772 NMOSWRAP
VG773 g773 0 0.6000000000000000
RB773 b773 0 10
X773 38 g773 10 b773 NMOSWRAP
VG774 g774 0 0.6000000000000000
RB774 b774 0 10
X774 38 g774 11 b774 NMOSWRAP
VG775 g775 0 0.6000000000000000
RB775 b775 0 10
X775 38 g775 11 b775 NMOSWRAP
VG776 g776 0 0.6000000000000000
RB776 b776 0 10
X776 38 g776 11 b776 NMOSWRAP
VG777 g777 0 0.6000000000000000
RB777 b777 0 10
X777 38 g777 12 b777 NMOSWRAP
VG778 g778 0 0.6000000000000000
RB778 b778 0 10
X778 38 g778 12 b778 NMOSWRAP
VG779 g779 0 0.6000000000000000
RB779 b779 0 10
X779 38 g779 12 b779 NMOSWRAP
VG780 g780 0 0.6000000000000000
RB780 b780 0 10
X780 39 g780 3 b780 NMOSWRAP
VG781 g781 0 0.6000000000000000
RB781 b781 0 10
X781 39 g781 3 b781 NMOSWRAP
VG782 g782 0 0.6000000000000000
RB782 b782 0 10
X782 39 g782 3 b782 NMOSWRAP
VG783 g783 0 0.6000000000000000
RB783 b783 0 10
X783 39 g783 4 b783 NMOSWRAP
VG784 g784 0 0.6000000000000000
RB784 b784 0 10
X784 39 g784 4 b784 NMOSWRAP
VG785 g785 0 0.6000000000000000
RB785 b785 0 10
X785 39 g785 4 b785 NMOSWRAP
VG786 g786 0 0.6000000000000000
RB786 b786 0 10
X786 39 g786 5 b786 NMOSWRAP
VG787 g787 0 0.6000000000000000
RB787 b787 0 10
X787 39 g787 5 b787 NMOSWRAP
VG788 g788 0 0.6000000000000000
RB788 b788 0 10
X788 39 g788 5 b788 NMOSWRAP
VG789 g789 0 0.6000000000000000
RB789 b789 0 10
X789 39 g789 6 b789 NMOSWRAP
VG790 g790 0 0.6000000000000000
RB790 b790 0 10
X790 39 g790 6 b790 NMOSWRAP
VG791 g791 0 0.6000000000000000
RB791 b791 0 10
X791 39 g791 6 b791 NMOSWRAP
VG792 g792 0 0.6000000000000000
RB792 b792 0 10
X792 39 g792 7 b792 NMOSWRAP
VG793 g793 0 0.6000000000000000
RB793 b793 0 10
X793 39 g793 7 b793 NMOSWRAP
VG794 g794 0 0.6000000000000000
RB794 b794 0 10
X794 39 g794 7 b794 NMOSWRAP
VG795 g795 0 0.6000000000000000
RB795 b795 0 10
X795 39 g795 8 b795 NMOSWRAP
VG796 g796 0 0.6000000000000000
RB796 b796 0 10
X796 39 g796 8 b796 NMOSWRAP
VG797 g797 0 0.6000000000000000
RB797 b797 0 10
X797 39 g797 8 b797 NMOSWRAP
VG798 g798 0 0.6000000000000000
RB798 b798 0 10
X798 39 g798 9 b798 NMOSWRAP
VG799 g799 0 0.6000000000000000
RB799 b799 0 10
X799 39 g799 9 b799 NMOSWRAP
VG800 g800 0 0.6000000000000000
RB800 b800 0 10
X800 39 g800 9 b800 NMOSWRAP
VG801 g801 0 0.6000000000000000
RB801 b801 0 10
X801 39 g801 10 b801 NMOSWRAP
VG802 g802 0 0.6000000000000000
RB802 b802 0 10
X802 39 g802 10 b802 NMOSWRAP
VG803 g803 0 0.6000000000000000
RB803 b803 0 10
X803 39 g803 10 b803 NMOSWRAP
VG804 g804 0 0.6000000000000000
RB804 b804 0 10
X804 39 g804 11 b804 NMOSWRAP
VG805 g805 0 0.6000000000000000
RB805 b805 0 10
X805 39 g805 11 b805 NMOSWRAP
VG806 g806 0 0.6000000000000000
RB806 b806 0 10
X806 39 g806 11 b806 NMOSWRAP
VG807 g807 0 0.6000000000000000
RB807 b807 0 10
X807 39 g807 12 b807 NMOSWRAP
VG808 g808 0 0.6000000000000000
RB808 b808 0 10
X808 39 g808 12 b808 NMOSWRAP
VG809 g809 0 0.6000000000000000
RB809 b809 0 10
X809 39 g809 12 b809 NMOSWRAP
VG810 g810 0 0.6000000000000000
RB810 b810 0 10
X810 40 g810 3 b810 NMOSWRAP
VG811 g811 0 0.6000000000000000
RB811 b811 0 10
X811 40 g811 3 b811 NMOSWRAP
VG812 g812 0 0.6000000000000000
RB812 b812 0 10
X812 40 g812 3 b812 NMOSWRAP
VG813 g813 0 0.6000000000000000
RB813 b813 0 10
X813 40 g813 4 b813 NMOSWRAP
VG814 g814 0 0.6000000000000000
RB814 b814 0 10
X814 40 g814 4 b814 NMOSWRAP
VG815 g815 0 0.6000000000000000
RB815 b815 0 10
X815 40 g815 4 b815 NMOSWRAP
VG816 g816 0 0.6000000000000000
RB816 b816 0 10
X816 40 g816 5 b816 NMOSWRAP
VG817 g817 0 0.6000000000000000
RB817 b817 0 10
X817 40 g817 5 b817 NMOSWRAP
VG818 g818 0 0.6000000000000000
RB818 b818 0 10
X818 40 g818 5 b818 NMOSWRAP
VG819 g819 0 0.6000000000000000
RB819 b819 0 10
X819 40 g819 6 b819 NMOSWRAP
VG820 g820 0 0.6000000000000000
RB820 b820 0 10
X820 40 g820 6 b820 NMOSWRAP
VG821 g821 0 0.6000000000000000
RB821 b821 0 10
X821 40 g821 6 b821 NMOSWRAP
VG822 g822 0 0.6000000000000000
RB822 b822 0 10
X822 40 g822 7 b822 NMOSWRAP
VG823 g823 0 0.6000000000000000
RB823 b823 0 10
X823 40 g823 7 b823 NMOSWRAP
VG824 g824 0 0.6000000000000000
RB824 b824 0 10
X824 40 g824 7 b824 NMOSWRAP
VG825 g825 0 0.6000000000000000
RB825 b825 0 10
X825 40 g825 8 b825 NMOSWRAP
VG826 g826 0 0.6000000000000000
RB826 b826 0 10
X826 40 g826 8 b826 NMOSWRAP
VG827 g827 0 0.6000000000000000
RB827 b827 0 10
X827 40 g827 8 b827 NMOSWRAP
VG828 g828 0 0.6000000000000000
RB828 b828 0 10
X828 40 g828 9 b828 NMOSWRAP
VG829 g829 0 0.6000000000000000
RB829 b829 0 10
X829 40 g829 9 b829 NMOSWRAP
VG830 g830 0 0.6000000000000000
RB830 b830 0 10
X830 40 g830 9 b830 NMOSWRAP
VG831 g831 0 0.6000000000000000
RB831 b831 0 10
X831 40 g831 10 b831 NMOSWRAP
VG832 g832 0 0.6000000000000000
RB832 b832 0 10
X832 40 g832 10 b832 NMOSWRAP
VG833 g833 0 0.6000000000000000
RB833 b833 0 10
X833 40 g833 10 b833 NMOSWRAP
VG834 g834 0 0.6000000000000000
RB834 b834 0 10
X834 40 g834 11 b834 NMOSWRAP
VG835 g835 0 0.6000000000000000
RB835 b835 0 10
X835 40 g835 11 b835 NMOSWRAP
VG836 g836 0 0.6000000000000000
RB836 b836 0 10
X836 40 g836 11 b836 NMOSWRAP
VG837 g837 0 0.6000000000000000
RB837 b837 0 10
X837 40 g837 12 b837 NMOSWRAP
VG838 g838 0 0.6000000000000000
RB838 b838 0 10
X838 40 g838 12 b838 NMOSWRAP
VG839 g839 0 0.6000000000000000
RB839 b839 0 10
X839 40 g839 12 b839 NMOSWRAP
VG840 g840 0 0.6000000000000000
RB840 b840 0 10
X840 41 g840 3 b840 NMOSWRAP
VG841 g841 0 0.6000000000000000
RB841 b841 0 10
X841 41 g841 3 b841 NMOSWRAP
VG842 g842 0 0.6000000000000000
RB842 b842 0 10
X842 41 g842 3 b842 NMOSWRAP
VG843 g843 0 0.6000000000000000
RB843 b843 0 10
X843 41 g843 4 b843 NMOSWRAP
VG844 g844 0 0.6000000000000000
RB844 b844 0 10
X844 41 g844 4 b844 NMOSWRAP
VG845 g845 0 0.6000000000000000
RB845 b845 0 10
X845 41 g845 4 b845 NMOSWRAP
VG846 g846 0 0.6000000000000000
RB846 b846 0 10
X846 41 g846 5 b846 NMOSWRAP
VG847 g847 0 0.6000000000000000
RB847 b847 0 10
X847 41 g847 5 b847 NMOSWRAP
VG848 g848 0 0.6000000000000000
RB848 b848 0 10
X848 41 g848 5 b848 NMOSWRAP
VG849 g849 0 0.6000000000000000
RB849 b849 0 10
X849 41 g849 6 b849 NMOSWRAP
VG850 g850 0 0.6000000000000000
RB850 b850 0 10
X850 41 g850 6 b850 NMOSWRAP
VG851 g851 0 0.6000000000000000
RB851 b851 0 10
X851 41 g851 6 b851 NMOSWRAP
VG852 g852 0 0.6000000000000000
RB852 b852 0 10
X852 41 g852 7 b852 NMOSWRAP
VG853 g853 0 0.6000000000000000
RB853 b853 0 10
X853 41 g853 7 b853 NMOSWRAP
VG854 g854 0 0.6000000000000000
RB854 b854 0 10
X854 41 g854 7 b854 NMOSWRAP
VG855 g855 0 0.6000000000000000
RB855 b855 0 10
X855 41 g855 8 b855 NMOSWRAP
VG856 g856 0 0.6000000000000000
RB856 b856 0 10
X856 41 g856 8 b856 NMOSWRAP
VG857 g857 0 0.6000000000000000
RB857 b857 0 10
X857 41 g857 8 b857 NMOSWRAP
VG858 g858 0 0.6000000000000000
RB858 b858 0 10
X858 41 g858 9 b858 NMOSWRAP
VG859 g859 0 0.6000000000000000
RB859 b859 0 10
X859 41 g859 9 b859 NMOSWRAP
VG860 g860 0 0.6000000000000000
RB860 b860 0 10
X860 41 g860 9 b860 NMOSWRAP
VG861 g861 0 0.6000000000000000
RB861 b861 0 10
X861 41 g861 10 b861 NMOSWRAP
VG862 g862 0 0.6000000000000000
RB862 b862 0 10
X862 41 g862 10 b862 NMOSWRAP
VG863 g863 0 0.6000000000000000
RB863 b863 0 10
X863 41 g863 10 b863 NMOSWRAP
VG864 g864 0 0.6000000000000000
RB864 b864 0 10
X864 41 g864 11 b864 NMOSWRAP
VG865 g865 0 0.6000000000000000
RB865 b865 0 10
X865 41 g865 11 b865 NMOSWRAP
VG866 g866 0 0.6000000000000000
RB866 b866 0 10
X866 41 g866 11 b866 NMOSWRAP
VG867 g867 0 0.6000000000000000
RB867 b867 0 10
X867 41 g867 12 b867 NMOSWRAP
VG868 g868 0 0.6000000000000000
RB868 b868 0 10
X868 41 g868 12 b868 NMOSWRAP
VG869 g869 0 0.6000000000000000
RB869 b869 0 10
X869 41 g869 12 b869 NMOSWRAP
VG870 g870 0 0.6000000000000000
RB870 b870 0 10
X870 42 g870 3 b870 NMOSWRAP
VG871 g871 0 0.6000000000000000
RB871 b871 0 10
X871 42 g871 3 b871 NMOSWRAP
VG872 g872 0 0.6000000000000000
RB872 b872 0 10
X872 42 g872 3 b872 NMOSWRAP
VG873 g873 0 0.6000000000000000
RB873 b873 0 10
X873 42 g873 4 b873 NMOSWRAP
VG874 g874 0 0.6000000000000000
RB874 b874 0 10
X874 42 g874 4 b874 NMOSWRAP
VG875 g875 0 0.6000000000000000
RB875 b875 0 10
X875 42 g875 4 b875 NMOSWRAP
VG876 g876 0 0.6000000000000000
RB876 b876 0 10
X876 42 g876 5 b876 NMOSWRAP
VG877 g877 0 0.6000000000000000
RB877 b877 0 10
X877 42 g877 5 b877 NMOSWRAP
VG878 g878 0 0.6000000000000000
RB878 b878 0 10
X878 42 g878 5 b878 NMOSWRAP
VG879 g879 0 0.6000000000000000
RB879 b879 0 10
X879 42 g879 6 b879 NMOSWRAP
VG880 g880 0 0.6000000000000000
RB880 b880 0 10
X880 42 g880 6 b880 NMOSWRAP
VG881 g881 0 0.6000000000000000
RB881 b881 0 10
X881 42 g881 6 b881 NMOSWRAP
VG882 g882 0 0.6000000000000000
RB882 b882 0 10
X882 42 g882 7 b882 NMOSWRAP
VG883 g883 0 0.6000000000000000
RB883 b883 0 10
X883 42 g883 7 b883 NMOSWRAP
VG884 g884 0 0.6000000000000000
RB884 b884 0 10
X884 42 g884 7 b884 NMOSWRAP
VG885 g885 0 0.6000000000000000
RB885 b885 0 10
X885 42 g885 8 b885 NMOSWRAP
VG886 g886 0 0.6000000000000000
RB886 b886 0 10
X886 42 g886 8 b886 NMOSWRAP
VG887 g887 0 0.6000000000000000
RB887 b887 0 10
X887 42 g887 8 b887 NMOSWRAP
VG888 g888 0 0.6000000000000000
RB888 b888 0 10
X888 42 g888 9 b888 NMOSWRAP
VG889 g889 0 0.6000000000000000
RB889 b889 0 10
X889 42 g889 9 b889 NMOSWRAP
VG890 g890 0 0.6000000000000000
RB890 b890 0 10
X890 42 g890 9 b890 NMOSWRAP
VG891 g891 0 0.6000000000000000
RB891 b891 0 10
X891 42 g891 10 b891 NMOSWRAP
VG892 g892 0 0.6000000000000000
RB892 b892 0 10
X892 42 g892 10 b892 NMOSWRAP
VG893 g893 0 0.6000000000000000
RB893 b893 0 10
X893 42 g893 10 b893 NMOSWRAP
VG894 g894 0 0.6000000000000000
RB894 b894 0 10
X894 42 g894 11 b894 NMOSWRAP
VG895 g895 0 0.6000000000000000
RB895 b895 0 10
X895 42 g895 11 b895 NMOSWRAP
VG896 g896 0 0.6000000000000000
RB896 b896 0 10
X896 42 g896 11 b896 NMOSWRAP
VG897 g897 0 0.6000000000000000
RB897 b897 0 10
X897 42 g897 12 b897 NMOSWRAP
VG898 g898 0 0.6000000000000000
RB898 b898 0 10
X898 42 g898 12 b898 NMOSWRAP
VG899 g899 0 0.6000000000000000
RB899 b899 0 10
X899 42 g899 12 b899 NMOSWRAP
VG900 g900 0 0.6000000000000000
RB900 b900 0 10
X900 43 g900 3 b900 NMOSWRAP
VG901 g901 0 0.6000000000000000
RB901 b901 0 10
X901 43 g901 3 b901 NMOSWRAP
VG902 g902 0 0.6000000000000000
RB902 b902 0 10
X902 43 g902 3 b902 NMOSWRAP
VG903 g903 0 0.6000000000000000
RB903 b903 0 10
X903 43 g903 4 b903 NMOSWRAP
VG904 g904 0 0.6000000000000000
RB904 b904 0 10
X904 43 g904 4 b904 NMOSWRAP
VG905 g905 0 0.6000000000000000
RB905 b905 0 10
X905 43 g905 4 b905 NMOSWRAP
VG906 g906 0 0.6000000000000000
RB906 b906 0 10
X906 43 g906 5 b906 NMOSWRAP
VG907 g907 0 0.6000000000000000
RB907 b907 0 10
X907 43 g907 5 b907 NMOSWRAP
VG908 g908 0 0.6000000000000000
RB908 b908 0 10
X908 43 g908 5 b908 NMOSWRAP
VG909 g909 0 0.6000000000000000
RB909 b909 0 10
X909 43 g909 6 b909 NMOSWRAP
VG910 g910 0 0.6000000000000000
RB910 b910 0 10
X910 43 g910 6 b910 NMOSWRAP
VG911 g911 0 0.6000000000000000
RB911 b911 0 10
X911 43 g911 6 b911 NMOSWRAP
VG912 g912 0 0.6000000000000000
RB912 b912 0 10
X912 43 g912 7 b912 NMOSWRAP
VG913 g913 0 0.6000000000000000
RB913 b913 0 10
X913 43 g913 7 b913 NMOSWRAP
VG914 g914 0 0.6000000000000000
RB914 b914 0 10
X914 43 g914 7 b914 NMOSWRAP
VG915 g915 0 0.6000000000000000
RB915 b915 0 10
X915 43 g915 8 b915 NMOSWRAP
VG916 g916 0 0.6000000000000000
RB916 b916 0 10
X916 43 g916 8 b916 NMOSWRAP
VG917 g917 0 0.6000000000000000
RB917 b917 0 10
X917 43 g917 8 b917 NMOSWRAP
VG918 g918 0 0.6000000000000000
RB918 b918 0 10
X918 43 g918 9 b918 NMOSWRAP
VG919 g919 0 0.6000000000000000
RB919 b919 0 10
X919 43 g919 9 b919 NMOSWRAP
VG920 g920 0 0.6000000000000000
RB920 b920 0 10
X920 43 g920 9 b920 NMOSWRAP
VG921 g921 0 0.6000000000000000
RB921 b921 0 10
X921 43 g921 10 b921 NMOSWRAP
VG922 g922 0 0.6000000000000000
RB922 b922 0 10
X922 43 g922 10 b922 NMOSWRAP
VG923 g923 0 0.6000000000000000
RB923 b923 0 10
X923 43 g923 10 b923 NMOSWRAP
VG924 g924 0 0.6000000000000000
RB924 b924 0 10
X924 43 g924 11 b924 NMOSWRAP
VG925 g925 0 0.6000000000000000
RB925 b925 0 10
X925 43 g925 11 b925 NMOSWRAP
VG926 g926 0 0.6000000000000000
RB926 b926 0 10
X926 43 g926 11 b926 NMOSWRAP
VG927 g927 0 0.6000000000000000
RB927 b927 0 10
X927 43 g927 12 b927 NMOSWRAP
VG928 g928 0 0.6000000000000000
RB928 b928 0 10
X928 43 g928 12 b928 NMOSWRAP
VG929 g929 0 0.6000000000000000
RB929 b929 0 10
X929 43 g929 12 b929 NMOSWRAP
VG930 g930 0 0.6000000000000000
RB930 b930 0 10
X930 44 g930 3 b930 NMOSWRAP
VG931 g931 0 0.6000000000000000
RB931 b931 0 10
X931 44 g931 3 b931 NMOSWRAP
VG932 g932 0 0.6000000000000000
RB932 b932 0 10
X932 44 g932 3 b932 NMOSWRAP
VG933 g933 0 0.6000000000000000
RB933 b933 0 10
X933 44 g933 4 b933 NMOSWRAP
VG934 g934 0 0.6000000000000000
RB934 b934 0 10
X934 44 g934 4 b934 NMOSWRAP
VG935 g935 0 0.6000000000000000
RB935 b935 0 10
X935 44 g935 4 b935 NMOSWRAP
VG936 g936 0 0.6000000000000000
RB936 b936 0 10
X936 44 g936 5 b936 NMOSWRAP
VG937 g937 0 0.6000000000000000
RB937 b937 0 10
X937 44 g937 5 b937 NMOSWRAP
VG938 g938 0 0.6000000000000000
RB938 b938 0 10
X938 44 g938 5 b938 NMOSWRAP
VG939 g939 0 0.6000000000000000
RB939 b939 0 10
X939 44 g939 6 b939 NMOSWRAP
VG940 g940 0 0.6000000000000000
RB940 b940 0 10
X940 44 g940 6 b940 NMOSWRAP
VG941 g941 0 0.6000000000000000
RB941 b941 0 10
X941 44 g941 6 b941 NMOSWRAP
VG942 g942 0 0.6000000000000000
RB942 b942 0 10
X942 44 g942 7 b942 NMOSWRAP
VG943 g943 0 0.6000000000000000
RB943 b943 0 10
X943 44 g943 7 b943 NMOSWRAP
VG944 g944 0 0.6000000000000000
RB944 b944 0 10
X944 44 g944 7 b944 NMOSWRAP
VG945 g945 0 0.6000000000000000
RB945 b945 0 10
X945 44 g945 8 b945 NMOSWRAP
VG946 g946 0 0.6000000000000000
RB946 b946 0 10
X946 44 g946 8 b946 NMOSWRAP
VG947 g947 0 0.6000000000000000
RB947 b947 0 10
X947 44 g947 8 b947 NMOSWRAP
VG948 g948 0 0.6000000000000000
RB948 b948 0 10
X948 44 g948 9 b948 NMOSWRAP
VG949 g949 0 0.6000000000000000
RB949 b949 0 10
X949 44 g949 9 b949 NMOSWRAP
VG950 g950 0 0.6000000000000000
RB950 b950 0 10
X950 44 g950 9 b950 NMOSWRAP
VG951 g951 0 0.6000000000000000
RB951 b951 0 10
X951 44 g951 10 b951 NMOSWRAP
VG952 g952 0 0.6000000000000000
RB952 b952 0 10
X952 44 g952 10 b952 NMOSWRAP
VG953 g953 0 0.6000000000000000
RB953 b953 0 10
X953 44 g953 10 b953 NMOSWRAP
VG954 g954 0 0.6000000000000000
RB954 b954 0 10
X954 44 g954 11 b954 NMOSWRAP
VG955 g955 0 0.6000000000000000
RB955 b955 0 10
X955 44 g955 11 b955 NMOSWRAP
VG956 g956 0 0.6000000000000000
RB956 b956 0 10
X956 44 g956 11 b956 NMOSWRAP
VG957 g957 0 0.6000000000000000
RB957 b957 0 10
X957 44 g957 12 b957 NMOSWRAP
VG958 g958 0 0.6000000000000000
RB958 b958 0 10
X958 44 g958 12 b958 NMOSWRAP
VG959 g959 0 0.6000000000000000
RB959 b959 0 10
X959 44 g959 12 b959 NMOSWRAP
VG960 g960 0 0.6000000000000000
RB960 b960 0 10
X960 45 g960 3 b960 NMOSWRAP
VG961 g961 0 0.6000000000000000
RB961 b961 0 10
X961 45 g961 3 b961 NMOSWRAP
VG962 g962 0 0.6000000000000000
RB962 b962 0 10
X962 45 g962 3 b962 NMOSWRAP
VG963 g963 0 0.6000000000000000
RB963 b963 0 10
X963 45 g963 4 b963 NMOSWRAP
VG964 g964 0 0.6000000000000000
RB964 b964 0 10
X964 45 g964 4 b964 NMOSWRAP
VG965 g965 0 0.6000000000000000
RB965 b965 0 10
X965 45 g965 4 b965 NMOSWRAP
VG966 g966 0 0.6000000000000000
RB966 b966 0 10
X966 45 g966 5 b966 NMOSWRAP
VG967 g967 0 0.6000000000000000
RB967 b967 0 10
X967 45 g967 5 b967 NMOSWRAP
VG968 g968 0 0.6000000000000000
RB968 b968 0 10
X968 45 g968 5 b968 NMOSWRAP
VG969 g969 0 0.6000000000000000
RB969 b969 0 10
X969 45 g969 6 b969 NMOSWRAP
VG970 g970 0 0.6000000000000000
RB970 b970 0 10
X970 45 g970 6 b970 NMOSWRAP
VG971 g971 0 0.6000000000000000
RB971 b971 0 10
X971 45 g971 6 b971 NMOSWRAP
VG972 g972 0 0.6000000000000000
RB972 b972 0 10
X972 45 g972 7 b972 NMOSWRAP
VG973 g973 0 0.6000000000000000
RB973 b973 0 10
X973 45 g973 7 b973 NMOSWRAP
VG974 g974 0 0.6000000000000000
RB974 b974 0 10
X974 45 g974 7 b974 NMOSWRAP
VG975 g975 0 0.6000000000000000
RB975 b975 0 10
X975 45 g975 8 b975 NMOSWRAP
VG976 g976 0 0.6000000000000000
RB976 b976 0 10
X976 45 g976 8 b976 NMOSWRAP
VG977 g977 0 0.6000000000000000
RB977 b977 0 10
X977 45 g977 8 b977 NMOSWRAP
VG978 g978 0 0.6000000000000000
RB978 b978 0 10
X978 45 g978 9 b978 NMOSWRAP
VG979 g979 0 0.6000000000000000
RB979 b979 0 10
X979 45 g979 9 b979 NMOSWRAP
VG980 g980 0 0.6000000000000000
RB980 b980 0 10
X980 45 g980 9 b980 NMOSWRAP
VG981 g981 0 0.6000000000000000
RB981 b981 0 10
X981 45 g981 10 b981 NMOSWRAP
VG982 g982 0 0.6000000000000000
RB982 b982 0 10
X982 45 g982 10 b982 NMOSWRAP
VG983 g983 0 0.6000000000000000
RB983 b983 0 10
X983 45 g983 10 b983 NMOSWRAP
VG984 g984 0 0.6000000000000000
RB984 b984 0 10
X984 45 g984 11 b984 NMOSWRAP
VG985 g985 0 0.6000000000000000
RB985 b985 0 10
X985 45 g985 11 b985 NMOSWRAP
VG986 g986 0 0.6000000000000000
RB986 b986 0 10
X986 45 g986 11 b986 NMOSWRAP
VG987 g987 0 0.6000000000000000
RB987 b987 0 10
X987 45 g987 12 b987 NMOSWRAP
VG988 g988 0 0.6000000000000000
RB988 b988 0 10
X988 45 g988 12 b988 NMOSWRAP
VG989 g989 0 0.6000000000000000
RB989 b989 0 10
X989 45 g989 12 b989 NMOSWRAP
VG990 g990 0 0.6000000000000000
RB990 b990 0 10
X990 46 g990 3 b990 NMOSWRAP
VG991 g991 0 0.6000000000000000
RB991 b991 0 10
X991 46 g991 3 b991 NMOSWRAP
VG992 g992 0 0.6000000000000000
RB992 b992 0 10
X992 46 g992 3 b992 NMOSWRAP
VG993 g993 0 0.6000000000000000
RB993 b993 0 10
X993 46 g993 4 b993 NMOSWRAP
VG994 g994 0 0.6000000000000000
RB994 b994 0 10
X994 46 g994 4 b994 NMOSWRAP
VG995 g995 0 0.6000000000000000
RB995 b995 0 10
X995 46 g995 4 b995 NMOSWRAP
VG996 g996 0 0.6000000000000000
RB996 b996 0 10
X996 46 g996 5 b996 NMOSWRAP
VG997 g997 0 0.6000000000000000
RB997 b997 0 10
X997 46 g997 5 b997 NMOSWRAP
VG998 g998 0 0.6000000000000000
RB998 b998 0 10
X998 46 g998 5 b998 NMOSWRAP
VG999 g999 0 0.6000000000000000
RB999 b999 0 10
X999 46 g999 6 b999 NMOSWRAP
VG1000 g1000 0 0.6000000000000000
RB1000 b1000 0 10
X1000 46 g1000 6 b1000 NMOSWRAP
VG1001 g1001 0 0.6000000000000000
RB1001 b1001 0 10
X1001 46 g1001 6 b1001 NMOSWRAP
VG1002 g1002 0 0.6000000000000000
RB1002 b1002 0 10
X1002 46 g1002 7 b1002 NMOSWRAP
VG1003 g1003 0 0.6000000000000000
RB1003 b1003 0 10
X1003 46 g1003 7 b1003 NMOSWRAP
VG1004 g1004 0 0.6000000000000000
RB1004 b1004 0 10
X1004 46 g1004 7 b1004 NMOSWRAP
VG1005 g1005 0 0.6000000000000000
RB1005 b1005 0 10
X1005 46 g1005 8 b1005 NMOSWRAP
VG1006 g1006 0 0.6000000000000000
RB1006 b1006 0 10
X1006 46 g1006 8 b1006 NMOSWRAP
VG1007 g1007 0 0.6000000000000000
RB1007 b1007 0 10
X1007 46 g1007 8 b1007 NMOSWRAP
VG1008 g1008 0 0.6000000000000000
RB1008 b1008 0 10
X1008 46 g1008 9 b1008 NMOSWRAP
VG1009 g1009 0 0.6000000000000000
RB1009 b1009 0 10
X1009 46 g1009 9 b1009 NMOSWRAP
VG1010 g1010 0 0.6000000000000000
RB1010 b1010 0 10
X1010 46 g1010 9 b1010 NMOSWRAP
VG1011 g1011 0 0.6000000000000000
RB1011 b1011 0 10
X1011 46 g1011 10 b1011 NMOSWRAP
VG1012 g1012 0 0.6000000000000000
RB1012 b1012 0 10
X1012 46 g1012 10 b1012 NMOSWRAP
VG1013 g1013 0 0.6000000000000000
RB1013 b1013 0 10
X1013 46 g1013 10 b1013 NMOSWRAP
VG1014 g1014 0 0.6000000000000000
RB1014 b1014 0 10
X1014 46 g1014 11 b1014 NMOSWRAP
VG1015 g1015 0 0.6000000000000000
RB1015 b1015 0 10
X1015 46 g1015 11 b1015 NMOSWRAP
VG1016 g1016 0 0.6000000000000000
RB1016 b1016 0 10
X1016 46 g1016 11 b1016 NMOSWRAP
VG1017 g1017 0 0.6000000000000000
RB1017 b1017 0 10
X1017 46 g1017 12 b1017 NMOSWRAP
VG1018 g1018 0 0.6000000000000000
RB1018 b1018 0 10
X1018 46 g1018 12 b1018 NMOSWRAP
VG1019 g1019 0 0.6000000000000000
RB1019 b1019 0 10
X1019 46 g1019 12 b1019 NMOSWRAP
VG1020 g1020 0 0.6000000000000000
RB1020 b1020 0 10
X1020 47 g1020 3 b1020 NMOSWRAP
VG1021 g1021 0 0.6000000000000000
RB1021 b1021 0 10
X1021 47 g1021 3 b1021 NMOSWRAP
VG1022 g1022 0 0.6000000000000000
RB1022 b1022 0 10
X1022 47 g1022 3 b1022 NMOSWRAP
VG1023 g1023 0 0.6000000000000000
RB1023 b1023 0 10
X1023 47 g1023 4 b1023 NMOSWRAP
VG1024 g1024 0 0.6000000000000000
RB1024 b1024 0 10
X1024 47 g1024 4 b1024 NMOSWRAP
VG1025 g1025 0 0.6000000000000000
RB1025 b1025 0 10
X1025 47 g1025 4 b1025 NMOSWRAP
VG1026 g1026 0 0.6000000000000000
RB1026 b1026 0 10
X1026 47 g1026 5 b1026 NMOSWRAP
VG1027 g1027 0 0.6000000000000000
RB1027 b1027 0 10
X1027 47 g1027 5 b1027 NMOSWRAP
VG1028 g1028 0 0.6000000000000000
RB1028 b1028 0 10
X1028 47 g1028 5 b1028 NMOSWRAP
VG1029 g1029 0 0.6000000000000000
RB1029 b1029 0 10
X1029 47 g1029 6 b1029 NMOSWRAP
VG1030 g1030 0 0.6000000000000000
RB1030 b1030 0 10
X1030 47 g1030 6 b1030 NMOSWRAP
VG1031 g1031 0 0.6000000000000000
RB1031 b1031 0 10
X1031 47 g1031 6 b1031 NMOSWRAP
VG1032 g1032 0 0.6000000000000000
RB1032 b1032 0 10
X1032 47 g1032 7 b1032 NMOSWRAP
VG1033 g1033 0 0.6000000000000000
RB1033 b1033 0 10
X1033 47 g1033 7 b1033 NMOSWRAP
VG1034 g1034 0 0.6000000000000000
RB1034 b1034 0 10
X1034 47 g1034 7 b1034 NMOSWRAP
VG1035 g1035 0 0.6000000000000000
RB1035 b1035 0 10
X1035 47 g1035 8 b1035 NMOSWRAP
VG1036 g1036 0 0.6000000000000000
RB1036 b1036 0 10
X1036 47 g1036 8 b1036 NMOSWRAP
VG1037 g1037 0 0.6000000000000000
RB1037 b1037 0 10
X1037 47 g1037 8 b1037 NMOSWRAP
VG1038 g1038 0 0.6000000000000000
RB1038 b1038 0 10
X1038 47 g1038 9 b1038 NMOSWRAP
VG1039 g1039 0 0.6000000000000000
RB1039 b1039 0 10
X1039 47 g1039 9 b1039 NMOSWRAP
VG1040 g1040 0 0.6000000000000000
RB1040 b1040 0 10
X1040 47 g1040 9 b1040 NMOSWRAP
VG1041 g1041 0 0.6000000000000000
RB1041 b1041 0 10
X1041 47 g1041 10 b1041 NMOSWRAP
VG1042 g1042 0 0.6000000000000000
RB1042 b1042 0 10
X1042 47 g1042 10 b1042 NMOSWRAP
VG1043 g1043 0 0.6000000000000000
RB1043 b1043 0 10
X1043 47 g1043 10 b1043 NMOSWRAP
VG1044 g1044 0 0.6000000000000000
RB1044 b1044 0 10
X1044 47 g1044 11 b1044 NMOSWRAP
VG1045 g1045 0 0.6000000000000000
RB1045 b1045 0 10
X1045 47 g1045 11 b1045 NMOSWRAP
VG1046 g1046 0 0.6000000000000000
RB1046 b1046 0 10
X1046 47 g1046 11 b1046 NMOSWRAP
VG1047 g1047 0 0.6000000000000000
RB1047 b1047 0 10
X1047 47 g1047 12 b1047 NMOSWRAP
VG1048 g1048 0 0.6000000000000000
RB1048 b1048 0 10
X1048 47 g1048 12 b1048 NMOSWRAP
VG1049 g1049 0 0.6000000000000000
RB1049 b1049 0 10
X1049 47 g1049 12 b1049 NMOSWRAP
VG1050 g1050 0 0.6000000000000000
RB1050 b1050 0 10
X1050 48 g1050 3 b1050 NMOSWRAP
VG1051 g1051 0 0.6000000000000000
RB1051 b1051 0 10
X1051 48 g1051 3 b1051 NMOSWRAP
VG1052 g1052 0 0.6000000000000000
RB1052 b1052 0 10
X1052 48 g1052 3 b1052 NMOSWRAP
VG1053 g1053 0 0.6000000000000000
RB1053 b1053 0 10
X1053 48 g1053 4 b1053 NMOSWRAP
VG1054 g1054 0 0.6000000000000000
RB1054 b1054 0 10
X1054 48 g1054 4 b1054 NMOSWRAP
VG1055 g1055 0 0.6000000000000000
RB1055 b1055 0 10
X1055 48 g1055 4 b1055 NMOSWRAP
VG1056 g1056 0 0.6000000000000000
RB1056 b1056 0 10
X1056 48 g1056 5 b1056 NMOSWRAP
VG1057 g1057 0 0.6000000000000000
RB1057 b1057 0 10
X1057 48 g1057 5 b1057 NMOSWRAP
VG1058 g1058 0 0.6000000000000000
RB1058 b1058 0 10
X1058 48 g1058 5 b1058 NMOSWRAP
VG1059 g1059 0 0.6000000000000000
RB1059 b1059 0 10
X1059 48 g1059 6 b1059 NMOSWRAP
VG1060 g1060 0 0.6000000000000000
RB1060 b1060 0 10
X1060 48 g1060 6 b1060 NMOSWRAP
VG1061 g1061 0 0.6000000000000000
RB1061 b1061 0 10
X1061 48 g1061 6 b1061 NMOSWRAP
VG1062 g1062 0 0.6000000000000000
RB1062 b1062 0 10
X1062 48 g1062 7 b1062 NMOSWRAP
VG1063 g1063 0 0.6000000000000000
RB1063 b1063 0 10
X1063 48 g1063 7 b1063 NMOSWRAP
VG1064 g1064 0 0.6000000000000000
RB1064 b1064 0 10
X1064 48 g1064 7 b1064 NMOSWRAP
VG1065 g1065 0 0.6000000000000000
RB1065 b1065 0 10
X1065 48 g1065 8 b1065 NMOSWRAP
VG1066 g1066 0 0.6000000000000000
RB1066 b1066 0 10
X1066 48 g1066 8 b1066 NMOSWRAP
VG1067 g1067 0 0.6000000000000000
RB1067 b1067 0 10
X1067 48 g1067 8 b1067 NMOSWRAP
VG1068 g1068 0 0.6000000000000000
RB1068 b1068 0 10
X1068 48 g1068 9 b1068 NMOSWRAP
VG1069 g1069 0 0.6000000000000000
RB1069 b1069 0 10
X1069 48 g1069 9 b1069 NMOSWRAP
VG1070 g1070 0 0.6000000000000000
RB1070 b1070 0 10
X1070 48 g1070 9 b1070 NMOSWRAP
VG1071 g1071 0 0.6000000000000000
RB1071 b1071 0 10
X1071 48 g1071 10 b1071 NMOSWRAP
VG1072 g1072 0 0.6000000000000000
RB1072 b1072 0 10
X1072 48 g1072 10 b1072 NMOSWRAP
VG1073 g1073 0 0.6000000000000000
RB1073 b1073 0 10
X1073 48 g1073 10 b1073 NMOSWRAP
VG1074 g1074 0 0.6000000000000000
RB1074 b1074 0 10
X1074 48 g1074 11 b1074 NMOSWRAP
VG1075 g1075 0 0.6000000000000000
RB1075 b1075 0 10
X1075 48 g1075 11 b1075 NMOSWRAP
VG1076 g1076 0 0.6000000000000000
RB1076 b1076 0 10
X1076 48 g1076 11 b1076 NMOSWRAP
VG1077 g1077 0 0.6000000000000000
RB1077 b1077 0 10
X1077 48 g1077 12 b1077 NMOSWRAP
VG1078 g1078 0 0.6000000000000000
RB1078 b1078 0 10
X1078 48 g1078 12 b1078 NMOSWRAP
VG1079 g1079 0 0.6000000000000000
RB1079 b1079 0 10
X1079 48 g1079 12 b1079 NMOSWRAP
VG1080 g1080 0 0.6000000000000000
RB1080 b1080 0 10
X1080 49 g1080 3 b1080 NMOSWRAP
VG1081 g1081 0 0.6000000000000000
RB1081 b1081 0 10
X1081 49 g1081 3 b1081 NMOSWRAP
VG1082 g1082 0 0.6000000000000000
RB1082 b1082 0 10
X1082 49 g1082 3 b1082 NMOSWRAP
VG1083 g1083 0 0.6000000000000000
RB1083 b1083 0 10
X1083 49 g1083 4 b1083 NMOSWRAP
VG1084 g1084 0 0.6000000000000000
RB1084 b1084 0 10
X1084 49 g1084 4 b1084 NMOSWRAP
VG1085 g1085 0 0.6000000000000000
RB1085 b1085 0 10
X1085 49 g1085 4 b1085 NMOSWRAP
VG1086 g1086 0 0.6000000000000000
RB1086 b1086 0 10
X1086 49 g1086 5 b1086 NMOSWRAP
VG1087 g1087 0 0.6000000000000000
RB1087 b1087 0 10
X1087 49 g1087 5 b1087 NMOSWRAP
VG1088 g1088 0 0.6000000000000000
RB1088 b1088 0 10
X1088 49 g1088 5 b1088 NMOSWRAP
VG1089 g1089 0 0.6000000000000000
RB1089 b1089 0 10
X1089 49 g1089 6 b1089 NMOSWRAP
VG1090 g1090 0 0.6000000000000000
RB1090 b1090 0 10
X1090 49 g1090 6 b1090 NMOSWRAP
VG1091 g1091 0 0.6000000000000000
RB1091 b1091 0 10
X1091 49 g1091 6 b1091 NMOSWRAP
VG1092 g1092 0 0.6000000000000000
RB1092 b1092 0 10
X1092 49 g1092 7 b1092 NMOSWRAP
VG1093 g1093 0 0.6000000000000000
RB1093 b1093 0 10
X1093 49 g1093 7 b1093 NMOSWRAP
VG1094 g1094 0 0.6000000000000000
RB1094 b1094 0 10
X1094 49 g1094 7 b1094 NMOSWRAP
VG1095 g1095 0 0.6000000000000000
RB1095 b1095 0 10
X1095 49 g1095 8 b1095 NMOSWRAP
VG1096 g1096 0 0.6000000000000000
RB1096 b1096 0 10
X1096 49 g1096 8 b1096 NMOSWRAP
VG1097 g1097 0 0.6000000000000000
RB1097 b1097 0 10
X1097 49 g1097 8 b1097 NMOSWRAP
VG1098 g1098 0 0.6000000000000000
RB1098 b1098 0 10
X1098 49 g1098 9 b1098 NMOSWRAP
VG1099 g1099 0 0.6000000000000000
RB1099 b1099 0 10
X1099 49 g1099 9 b1099 NMOSWRAP
VG1100 g1100 0 0.6000000000000000
RB1100 b1100 0 10
X1100 49 g1100 9 b1100 NMOSWRAP
VG1101 g1101 0 0.6000000000000000
RB1101 b1101 0 10
X1101 49 g1101 10 b1101 NMOSWRAP
VG1102 g1102 0 0.6000000000000000
RB1102 b1102 0 10
X1102 49 g1102 10 b1102 NMOSWRAP
VG1103 g1103 0 0.6000000000000000
RB1103 b1103 0 10
X1103 49 g1103 10 b1103 NMOSWRAP
VG1104 g1104 0 0.6000000000000000
RB1104 b1104 0 10
X1104 49 g1104 11 b1104 NMOSWRAP
VG1105 g1105 0 0.6000000000000000
RB1105 b1105 0 10
X1105 49 g1105 11 b1105 NMOSWRAP
VG1106 g1106 0 0.6000000000000000
RB1106 b1106 0 10
X1106 49 g1106 11 b1106 NMOSWRAP
VG1107 g1107 0 0.6000000000000000
RB1107 b1107 0 10
X1107 49 g1107 12 b1107 NMOSWRAP
VG1108 g1108 0 0.6000000000000000
RB1108 b1108 0 10
X1108 49 g1108 12 b1108 NMOSWRAP
VG1109 g1109 0 0.6000000000000000
RB1109 b1109 0 10
X1109 49 g1109 12 b1109 NMOSWRAP
VG1110 g1110 0 0.6000000000000000
RB1110 b1110 0 10
X1110 50 g1110 3 b1110 NMOSWRAP
VG1111 g1111 0 0.6000000000000000
RB1111 b1111 0 10
X1111 50 g1111 3 b1111 NMOSWRAP
VG1112 g1112 0 0.6000000000000000
RB1112 b1112 0 10
X1112 50 g1112 3 b1112 NMOSWRAP
VG1113 g1113 0 0.6000000000000000
RB1113 b1113 0 10
X1113 50 g1113 4 b1113 NMOSWRAP
VG1114 g1114 0 0.6000000000000000
RB1114 b1114 0 10
X1114 50 g1114 4 b1114 NMOSWRAP
VG1115 g1115 0 0.6000000000000000
RB1115 b1115 0 10
X1115 50 g1115 4 b1115 NMOSWRAP
VG1116 g1116 0 0.6000000000000000
RB1116 b1116 0 10
X1116 50 g1116 5 b1116 NMOSWRAP
VG1117 g1117 0 0.6000000000000000
RB1117 b1117 0 10
X1117 50 g1117 5 b1117 NMOSWRAP
VG1118 g1118 0 0.6000000000000000
RB1118 b1118 0 10
X1118 50 g1118 5 b1118 NMOSWRAP
VG1119 g1119 0 0.6000000000000000
RB1119 b1119 0 10
X1119 50 g1119 6 b1119 NMOSWRAP
VG1120 g1120 0 0.6000000000000000
RB1120 b1120 0 10
X1120 50 g1120 6 b1120 NMOSWRAP
VG1121 g1121 0 0.6000000000000000
RB1121 b1121 0 10
X1121 50 g1121 6 b1121 NMOSWRAP
VG1122 g1122 0 0.6000000000000000
RB1122 b1122 0 10
X1122 50 g1122 7 b1122 NMOSWRAP
VG1123 g1123 0 0.6000000000000000
RB1123 b1123 0 10
X1123 50 g1123 7 b1123 NMOSWRAP
VG1124 g1124 0 0.6000000000000000
RB1124 b1124 0 10
X1124 50 g1124 7 b1124 NMOSWRAP
VG1125 g1125 0 0.6000000000000000
RB1125 b1125 0 10
X1125 50 g1125 8 b1125 NMOSWRAP
VG1126 g1126 0 0.6000000000000000
RB1126 b1126 0 10
X1126 50 g1126 8 b1126 NMOSWRAP
VG1127 g1127 0 0.6000000000000000
RB1127 b1127 0 10
X1127 50 g1127 8 b1127 NMOSWRAP
VG1128 g1128 0 0.6000000000000000
RB1128 b1128 0 10
X1128 50 g1128 9 b1128 NMOSWRAP
VG1129 g1129 0 0.6000000000000000
RB1129 b1129 0 10
X1129 50 g1129 9 b1129 NMOSWRAP
VG1130 g1130 0 0.6000000000000000
RB1130 b1130 0 10
X1130 50 g1130 9 b1130 NMOSWRAP
VG1131 g1131 0 0.6000000000000000
RB1131 b1131 0 10
X1131 50 g1131 10 b1131 NMOSWRAP
VG1132 g1132 0 0.6000000000000000
RB1132 b1132 0 10
X1132 50 g1132 10 b1132 NMOSWRAP
VG1133 g1133 0 0.6000000000000000
RB1133 b1133 0 10
X1133 50 g1133 10 b1133 NMOSWRAP
VG1134 g1134 0 0.6000000000000000
RB1134 b1134 0 10
X1134 50 g1134 11 b1134 NMOSWRAP
VG1135 g1135 0 0.6000000000000000
RB1135 b1135 0 10
X1135 50 g1135 11 b1135 NMOSWRAP
VG1136 g1136 0 0.6000000000000000
RB1136 b1136 0 10
X1136 50 g1136 11 b1136 NMOSWRAP
VG1137 g1137 0 0.6000000000000000
RB1137 b1137 0 10
X1137 50 g1137 12 b1137 NMOSWRAP
VG1138 g1138 0 0.6000000000000000
RB1138 b1138 0 10
X1138 50 g1138 12 b1138 NMOSWRAP
VG1139 g1139 0 0.6000000000000000
RB1139 b1139 0 10
X1139 50 g1139 12 b1139 NMOSWRAP
VG1140 g1140 0 0.6000000000000000
RB1140 b1140 0 10
X1140 51 g1140 3 b1140 NMOSWRAP
VG1141 g1141 0 0.6000000000000000
RB1141 b1141 0 10
X1141 51 g1141 3 b1141 NMOSWRAP
VG1142 g1142 0 0.6000000000000000
RB1142 b1142 0 10
X1142 51 g1142 3 b1142 NMOSWRAP
VG1143 g1143 0 0.6000000000000000
RB1143 b1143 0 10
X1143 51 g1143 4 b1143 NMOSWRAP
VG1144 g1144 0 0.6000000000000000
RB1144 b1144 0 10
X1144 51 g1144 4 b1144 NMOSWRAP
VG1145 g1145 0 0.6000000000000000
RB1145 b1145 0 10
X1145 51 g1145 4 b1145 NMOSWRAP
VG1146 g1146 0 0.6000000000000000
RB1146 b1146 0 10
X1146 51 g1146 5 b1146 NMOSWRAP
VG1147 g1147 0 0.6000000000000000
RB1147 b1147 0 10
X1147 51 g1147 5 b1147 NMOSWRAP
VG1148 g1148 0 0.6000000000000000
RB1148 b1148 0 10
X1148 51 g1148 5 b1148 NMOSWRAP
VG1149 g1149 0 0.6000000000000000
RB1149 b1149 0 10
X1149 51 g1149 6 b1149 NMOSWRAP
VG1150 g1150 0 0.6000000000000000
RB1150 b1150 0 10
X1150 51 g1150 6 b1150 NMOSWRAP
VG1151 g1151 0 0.6000000000000000
RB1151 b1151 0 10
X1151 51 g1151 6 b1151 NMOSWRAP
VG1152 g1152 0 0.6000000000000000
RB1152 b1152 0 10
X1152 51 g1152 7 b1152 NMOSWRAP
VG1153 g1153 0 0.6000000000000000
RB1153 b1153 0 10
X1153 51 g1153 7 b1153 NMOSWRAP
VG1154 g1154 0 0.6000000000000000
RB1154 b1154 0 10
X1154 51 g1154 7 b1154 NMOSWRAP
VG1155 g1155 0 0.6000000000000000
RB1155 b1155 0 10
X1155 51 g1155 8 b1155 NMOSWRAP
VG1156 g1156 0 0.6000000000000000
RB1156 b1156 0 10
X1156 51 g1156 8 b1156 NMOSWRAP
VG1157 g1157 0 0.6000000000000000
RB1157 b1157 0 10
X1157 51 g1157 8 b1157 NMOSWRAP
VG1158 g1158 0 0.6000000000000000
RB1158 b1158 0 10
X1158 51 g1158 9 b1158 NMOSWRAP
VG1159 g1159 0 0.6000000000000000
RB1159 b1159 0 10
X1159 51 g1159 9 b1159 NMOSWRAP
VG1160 g1160 0 0.6000000000000000
RB1160 b1160 0 10
X1160 51 g1160 9 b1160 NMOSWRAP
VG1161 g1161 0 0.6000000000000000
RB1161 b1161 0 10
X1161 51 g1161 10 b1161 NMOSWRAP
VG1162 g1162 0 0.6000000000000000
RB1162 b1162 0 10
X1162 51 g1162 10 b1162 NMOSWRAP
VG1163 g1163 0 0.6000000000000000
RB1163 b1163 0 10
X1163 51 g1163 10 b1163 NMOSWRAP
VG1164 g1164 0 0.6000000000000000
RB1164 b1164 0 10
X1164 51 g1164 11 b1164 NMOSWRAP
VG1165 g1165 0 0.6000000000000000
RB1165 b1165 0 10
X1165 51 g1165 11 b1165 NMOSWRAP
VG1166 g1166 0 0.6000000000000000
RB1166 b1166 0 10
X1166 51 g1166 11 b1166 NMOSWRAP
VG1167 g1167 0 0.6000000000000000
RB1167 b1167 0 10
X1167 51 g1167 12 b1167 NMOSWRAP
VG1168 g1168 0 0.6000000000000000
RB1168 b1168 0 10
X1168 51 g1168 12 b1168 NMOSWRAP
VG1169 g1169 0 0.6000000000000000
RB1169 b1169 0 10
X1169 51 g1169 12 b1169 NMOSWRAP
VG1170 g1170 0 0.6000000000000000
RB1170 b1170 0 10
X1170 52 g1170 3 b1170 NMOSWRAP
VG1171 g1171 0 0.6000000000000000
RB1171 b1171 0 10
X1171 52 g1171 3 b1171 NMOSWRAP
VG1172 g1172 0 0.6000000000000000
RB1172 b1172 0 10
X1172 52 g1172 3 b1172 NMOSWRAP
VG1173 g1173 0 0.6000000000000000
RB1173 b1173 0 10
X1173 52 g1173 4 b1173 NMOSWRAP
VG1174 g1174 0 0.6000000000000000
RB1174 b1174 0 10
X1174 52 g1174 4 b1174 NMOSWRAP
VG1175 g1175 0 0.6000000000000000
RB1175 b1175 0 10
X1175 52 g1175 4 b1175 NMOSWRAP
VG1176 g1176 0 0.6000000000000000
RB1176 b1176 0 10
X1176 52 g1176 5 b1176 NMOSWRAP
VG1177 g1177 0 0.6000000000000000
RB1177 b1177 0 10
X1177 52 g1177 5 b1177 NMOSWRAP
VG1178 g1178 0 0.6000000000000000
RB1178 b1178 0 10
X1178 52 g1178 5 b1178 NMOSWRAP
VG1179 g1179 0 0.6000000000000000
RB1179 b1179 0 10
X1179 52 g1179 6 b1179 NMOSWRAP
VG1180 g1180 0 0.6000000000000000
RB1180 b1180 0 10
X1180 52 g1180 6 b1180 NMOSWRAP
VG1181 g1181 0 0.6000000000000000
RB1181 b1181 0 10
X1181 52 g1181 6 b1181 NMOSWRAP
VG1182 g1182 0 0.6000000000000000
RB1182 b1182 0 10
X1182 52 g1182 7 b1182 NMOSWRAP
VG1183 g1183 0 0.6000000000000000
RB1183 b1183 0 10
X1183 52 g1183 7 b1183 NMOSWRAP
VG1184 g1184 0 0.6000000000000000
RB1184 b1184 0 10
X1184 52 g1184 7 b1184 NMOSWRAP
VG1185 g1185 0 0.6000000000000000
RB1185 b1185 0 10
X1185 52 g1185 8 b1185 NMOSWRAP
VG1186 g1186 0 0.6000000000000000
RB1186 b1186 0 10
X1186 52 g1186 8 b1186 NMOSWRAP
VG1187 g1187 0 0.6000000000000000
RB1187 b1187 0 10
X1187 52 g1187 8 b1187 NMOSWRAP
VG1188 g1188 0 0.6000000000000000
RB1188 b1188 0 10
X1188 52 g1188 9 b1188 NMOSWRAP
VG1189 g1189 0 0.6000000000000000
RB1189 b1189 0 10
X1189 52 g1189 9 b1189 NMOSWRAP
VG1190 g1190 0 0.6000000000000000
RB1190 b1190 0 10
X1190 52 g1190 9 b1190 NMOSWRAP
VG1191 g1191 0 0.6000000000000000
RB1191 b1191 0 10
X1191 52 g1191 10 b1191 NMOSWRAP
VG1192 g1192 0 0.6000000000000000
RB1192 b1192 0 10
X1192 52 g1192 10 b1192 NMOSWRAP
VG1193 g1193 0 0.6000000000000000
RB1193 b1193 0 10
X1193 52 g1193 10 b1193 NMOSWRAP
VG1194 g1194 0 0.6000000000000000
RB1194 b1194 0 10
X1194 52 g1194 11 b1194 NMOSWRAP
VG1195 g1195 0 0.6000000000000000
RB1195 b1195 0 10
X1195 52 g1195 11 b1195 NMOSWRAP
VG1196 g1196 0 0.6000000000000000
RB1196 b1196 0 10
X1196 52 g1196 11 b1196 NMOSWRAP
VG1197 g1197 0 0.6000000000000000
RB1197 b1197 0 10
X1197 52 g1197 12 b1197 NMOSWRAP
VG1198 g1198 0 0.6000000000000000
RB1198 b1198 0 10
X1198 52 g1198 12 b1198 NMOSWRAP
VG1199 g1199 0 0.6000000000000000
RB1199 b1199 0 10
X1199 52 g1199 12 b1199 NMOSWRAP
VG1200 g1200 0 0.6000000000000000
RB1200 b1200 0 10
X1200 53 g1200 3 b1200 NMOSWRAP
VG1201 g1201 0 0.6000000000000000
RB1201 b1201 0 10
X1201 53 g1201 3 b1201 NMOSWRAP
VG1202 g1202 0 0.6000000000000000
RB1202 b1202 0 10
X1202 53 g1202 3 b1202 NMOSWRAP
VG1203 g1203 0 0.6000000000000000
RB1203 b1203 0 10
X1203 53 g1203 4 b1203 NMOSWRAP
VG1204 g1204 0 0.6000000000000000
RB1204 b1204 0 10
X1204 53 g1204 4 b1204 NMOSWRAP
VG1205 g1205 0 0.6000000000000000
RB1205 b1205 0 10
X1205 53 g1205 4 b1205 NMOSWRAP
VG1206 g1206 0 0.6000000000000000
RB1206 b1206 0 10
X1206 53 g1206 5 b1206 NMOSWRAP
VG1207 g1207 0 0.6000000000000000
RB1207 b1207 0 10
X1207 53 g1207 5 b1207 NMOSWRAP
VG1208 g1208 0 0.6000000000000000
RB1208 b1208 0 10
X1208 53 g1208 5 b1208 NMOSWRAP
VG1209 g1209 0 0.6000000000000000
RB1209 b1209 0 10
X1209 53 g1209 6 b1209 NMOSWRAP
VG1210 g1210 0 0.6000000000000000
RB1210 b1210 0 10
X1210 53 g1210 6 b1210 NMOSWRAP
VG1211 g1211 0 0.6000000000000000
RB1211 b1211 0 10
X1211 53 g1211 6 b1211 NMOSWRAP
VG1212 g1212 0 0.6000000000000000
RB1212 b1212 0 10
X1212 53 g1212 7 b1212 NMOSWRAP
VG1213 g1213 0 0.6000000000000000
RB1213 b1213 0 10
X1213 53 g1213 7 b1213 NMOSWRAP
VG1214 g1214 0 0.6000000000000000
RB1214 b1214 0 10
X1214 53 g1214 7 b1214 NMOSWRAP
VG1215 g1215 0 0.6000000000000000
RB1215 b1215 0 10
X1215 53 g1215 8 b1215 NMOSWRAP
VG1216 g1216 0 0.6000000000000000
RB1216 b1216 0 10
X1216 53 g1216 8 b1216 NMOSWRAP
VG1217 g1217 0 0.6000000000000000
RB1217 b1217 0 10
X1217 53 g1217 8 b1217 NMOSWRAP
VG1218 g1218 0 0.6000000000000000
RB1218 b1218 0 10
X1218 53 g1218 9 b1218 NMOSWRAP
VG1219 g1219 0 0.6000000000000000
RB1219 b1219 0 10
X1219 53 g1219 9 b1219 NMOSWRAP
VG1220 g1220 0 0.6000000000000000
RB1220 b1220 0 10
X1220 53 g1220 9 b1220 NMOSWRAP
VG1221 g1221 0 0.6000000000000000
RB1221 b1221 0 10
X1221 53 g1221 10 b1221 NMOSWRAP
VG1222 g1222 0 0.6000000000000000
RB1222 b1222 0 10
X1222 53 g1222 10 b1222 NMOSWRAP
VG1223 g1223 0 0.6000000000000000
RB1223 b1223 0 10
X1223 53 g1223 10 b1223 NMOSWRAP
VG1224 g1224 0 0.6000000000000000
RB1224 b1224 0 10
X1224 53 g1224 11 b1224 NMOSWRAP
VG1225 g1225 0 0.6000000000000000
RB1225 b1225 0 10
X1225 53 g1225 11 b1225 NMOSWRAP
VG1226 g1226 0 0.6000000000000000
RB1226 b1226 0 10
X1226 53 g1226 11 b1226 NMOSWRAP
VG1227 g1227 0 0.6000000000000000
RB1227 b1227 0 10
X1227 53 g1227 12 b1227 NMOSWRAP
VG1228 g1228 0 0.6000000000000000
RB1228 b1228 0 10
X1228 53 g1228 12 b1228 NMOSWRAP
VG1229 g1229 0 0.6000000000000000
RB1229 b1229 0 10
X1229 53 g1229 12 b1229 NMOSWRAP
VG1230 g1230 0 0.6000000000000000
RB1230 b1230 0 10
X1230 54 g1230 3 b1230 NMOSWRAP
VG1231 g1231 0 0.6000000000000000
RB1231 b1231 0 10
X1231 54 g1231 3 b1231 NMOSWRAP
VG1232 g1232 0 0.6000000000000000
RB1232 b1232 0 10
X1232 54 g1232 3 b1232 NMOSWRAP
VG1233 g1233 0 0.6000000000000000
RB1233 b1233 0 10
X1233 54 g1233 4 b1233 NMOSWRAP
VG1234 g1234 0 0.6000000000000000
RB1234 b1234 0 10
X1234 54 g1234 4 b1234 NMOSWRAP
VG1235 g1235 0 0.6000000000000000
RB1235 b1235 0 10
X1235 54 g1235 4 b1235 NMOSWRAP
VG1236 g1236 0 0.6000000000000000
RB1236 b1236 0 10
X1236 54 g1236 5 b1236 NMOSWRAP
VG1237 g1237 0 0.6000000000000000
RB1237 b1237 0 10
X1237 54 g1237 5 b1237 NMOSWRAP
VG1238 g1238 0 0.6000000000000000
RB1238 b1238 0 10
X1238 54 g1238 5 b1238 NMOSWRAP
VG1239 g1239 0 0.6000000000000000
RB1239 b1239 0 10
X1239 54 g1239 6 b1239 NMOSWRAP
VG1240 g1240 0 0.6000000000000000
RB1240 b1240 0 10
X1240 54 g1240 6 b1240 NMOSWRAP
VG1241 g1241 0 0.6000000000000000
RB1241 b1241 0 10
X1241 54 g1241 6 b1241 NMOSWRAP
VG1242 g1242 0 0.6000000000000000
RB1242 b1242 0 10
X1242 54 g1242 7 b1242 NMOSWRAP
VG1243 g1243 0 0.6000000000000000
RB1243 b1243 0 10
X1243 54 g1243 7 b1243 NMOSWRAP
VG1244 g1244 0 0.6000000000000000
RB1244 b1244 0 10
X1244 54 g1244 7 b1244 NMOSWRAP
VG1245 g1245 0 0.6000000000000000
RB1245 b1245 0 10
X1245 54 g1245 8 b1245 NMOSWRAP
VG1246 g1246 0 0.6000000000000000
RB1246 b1246 0 10
X1246 54 g1246 8 b1246 NMOSWRAP
VG1247 g1247 0 0.6000000000000000
RB1247 b1247 0 10
X1247 54 g1247 8 b1247 NMOSWRAP
VG1248 g1248 0 0.6000000000000000
RB1248 b1248 0 10
X1248 54 g1248 9 b1248 NMOSWRAP
VG1249 g1249 0 0.6000000000000000
RB1249 b1249 0 10
X1249 54 g1249 9 b1249 NMOSWRAP
VG1250 g1250 0 0.6000000000000000
RB1250 b1250 0 10
X1250 54 g1250 9 b1250 NMOSWRAP
VG1251 g1251 0 0.6000000000000000
RB1251 b1251 0 10
X1251 54 g1251 10 b1251 NMOSWRAP
VG1252 g1252 0 0.6000000000000000
RB1252 b1252 0 10
X1252 54 g1252 10 b1252 NMOSWRAP
VG1253 g1253 0 0.6000000000000000
RB1253 b1253 0 10
X1253 54 g1253 10 b1253 NMOSWRAP
VG1254 g1254 0 0.6000000000000000
RB1254 b1254 0 10
X1254 54 g1254 11 b1254 NMOSWRAP
VG1255 g1255 0 0.6000000000000000
RB1255 b1255 0 10
X1255 54 g1255 11 b1255 NMOSWRAP
VG1256 g1256 0 0.6000000000000000
RB1256 b1256 0 10
X1256 54 g1256 11 b1256 NMOSWRAP
VG1257 g1257 0 0.6000000000000000
RB1257 b1257 0 10
X1257 54 g1257 12 b1257 NMOSWRAP
VG1258 g1258 0 0.6000000000000000
RB1258 b1258 0 10
X1258 54 g1258 12 b1258 NMOSWRAP
VG1259 g1259 0 0.6000000000000000
RB1259 b1259 0 10
X1259 54 g1259 12 b1259 NMOSWRAP
VG1260 g1260 0 0.6000000000000000
RB1260 b1260 0 10
X1260 55 g1260 3 b1260 NMOSWRAP
VG1261 g1261 0 0.6000000000000000
RB1261 b1261 0 10
X1261 55 g1261 3 b1261 NMOSWRAP
VG1262 g1262 0 0.6000000000000000
RB1262 b1262 0 10
X1262 55 g1262 3 b1262 NMOSWRAP
VG1263 g1263 0 0.6000000000000000
RB1263 b1263 0 10
X1263 55 g1263 4 b1263 NMOSWRAP
VG1264 g1264 0 0.6000000000000000
RB1264 b1264 0 10
X1264 55 g1264 4 b1264 NMOSWRAP
VG1265 g1265 0 0.6000000000000000
RB1265 b1265 0 10
X1265 55 g1265 4 b1265 NMOSWRAP
VG1266 g1266 0 0.6000000000000000
RB1266 b1266 0 10
X1266 55 g1266 5 b1266 NMOSWRAP
VG1267 g1267 0 0.6000000000000000
RB1267 b1267 0 10
X1267 55 g1267 5 b1267 NMOSWRAP
VG1268 g1268 0 0.6000000000000000
RB1268 b1268 0 10
X1268 55 g1268 5 b1268 NMOSWRAP
VG1269 g1269 0 0.6000000000000000
RB1269 b1269 0 10
X1269 55 g1269 6 b1269 NMOSWRAP
VG1270 g1270 0 0.6000000000000000
RB1270 b1270 0 10
X1270 55 g1270 6 b1270 NMOSWRAP
VG1271 g1271 0 0.6000000000000000
RB1271 b1271 0 10
X1271 55 g1271 6 b1271 NMOSWRAP
VG1272 g1272 0 0.6000000000000000
RB1272 b1272 0 10
X1272 55 g1272 7 b1272 NMOSWRAP
VG1273 g1273 0 0.6000000000000000
RB1273 b1273 0 10
X1273 55 g1273 7 b1273 NMOSWRAP
VG1274 g1274 0 0.6000000000000000
RB1274 b1274 0 10
X1274 55 g1274 7 b1274 NMOSWRAP
VG1275 g1275 0 0.6000000000000000
RB1275 b1275 0 10
X1275 55 g1275 8 b1275 NMOSWRAP
VG1276 g1276 0 0.6000000000000000
RB1276 b1276 0 10
X1276 55 g1276 8 b1276 NMOSWRAP
VG1277 g1277 0 0.6000000000000000
RB1277 b1277 0 10
X1277 55 g1277 8 b1277 NMOSWRAP
VG1278 g1278 0 0.6000000000000000
RB1278 b1278 0 10
X1278 55 g1278 9 b1278 NMOSWRAP
VG1279 g1279 0 0.6000000000000000
RB1279 b1279 0 10
X1279 55 g1279 9 b1279 NMOSWRAP
VG1280 g1280 0 0.6000000000000000
RB1280 b1280 0 10
X1280 55 g1280 9 b1280 NMOSWRAP
VG1281 g1281 0 0.6000000000000000
RB1281 b1281 0 10
X1281 55 g1281 10 b1281 NMOSWRAP
VG1282 g1282 0 0.6000000000000000
RB1282 b1282 0 10
X1282 55 g1282 10 b1282 NMOSWRAP
VG1283 g1283 0 0.6000000000000000
RB1283 b1283 0 10
X1283 55 g1283 10 b1283 NMOSWRAP
VG1284 g1284 0 0.6000000000000000
RB1284 b1284 0 10
X1284 55 g1284 11 b1284 NMOSWRAP
VG1285 g1285 0 0.6000000000000000
RB1285 b1285 0 10
X1285 55 g1285 11 b1285 NMOSWRAP
VG1286 g1286 0 0.6000000000000000
RB1286 b1286 0 10
X1286 55 g1286 11 b1286 NMOSWRAP
VG1287 g1287 0 0.6000000000000000
RB1287 b1287 0 10
X1287 55 g1287 12 b1287 NMOSWRAP
VG1288 g1288 0 0.6000000000000000
RB1288 b1288 0 10
X1288 55 g1288 12 b1288 NMOSWRAP
VG1289 g1289 0 0.6000000000000000
RB1289 b1289 0 10
X1289 55 g1289 12 b1289 NMOSWRAP
VG1290 g1290 0 0.6000000000000000
RB1290 b1290 0 10
X1290 56 g1290 3 b1290 NMOSWRAP
VG1291 g1291 0 0.6000000000000000
RB1291 b1291 0 10
X1291 56 g1291 3 b1291 NMOSWRAP
VG1292 g1292 0 0.6000000000000000
RB1292 b1292 0 10
X1292 56 g1292 3 b1292 NMOSWRAP
VG1293 g1293 0 0.6000000000000000
RB1293 b1293 0 10
X1293 56 g1293 4 b1293 NMOSWRAP
VG1294 g1294 0 0.6000000000000000
RB1294 b1294 0 10
X1294 56 g1294 4 b1294 NMOSWRAP
VG1295 g1295 0 0.6000000000000000
RB1295 b1295 0 10
X1295 56 g1295 4 b1295 NMOSWRAP
VG1296 g1296 0 0.6000000000000000
RB1296 b1296 0 10
X1296 56 g1296 5 b1296 NMOSWRAP
VG1297 g1297 0 0.6000000000000000
RB1297 b1297 0 10
X1297 56 g1297 5 b1297 NMOSWRAP
VG1298 g1298 0 0.6000000000000000
RB1298 b1298 0 10
X1298 56 g1298 5 b1298 NMOSWRAP
VG1299 g1299 0 0.6000000000000000
RB1299 b1299 0 10
X1299 56 g1299 6 b1299 NMOSWRAP
VG1300 g1300 0 0.6000000000000000
RB1300 b1300 0 10
X1300 56 g1300 6 b1300 NMOSWRAP
VG1301 g1301 0 0.6000000000000000
RB1301 b1301 0 10
X1301 56 g1301 6 b1301 NMOSWRAP
VG1302 g1302 0 0.6000000000000000
RB1302 b1302 0 10
X1302 56 g1302 7 b1302 NMOSWRAP
VG1303 g1303 0 0.6000000000000000
RB1303 b1303 0 10
X1303 56 g1303 7 b1303 NMOSWRAP
VG1304 g1304 0 0.6000000000000000
RB1304 b1304 0 10
X1304 56 g1304 7 b1304 NMOSWRAP
VG1305 g1305 0 0.6000000000000000
RB1305 b1305 0 10
X1305 56 g1305 8 b1305 NMOSWRAP
VG1306 g1306 0 0.6000000000000000
RB1306 b1306 0 10
X1306 56 g1306 8 b1306 NMOSWRAP
VG1307 g1307 0 0.6000000000000000
RB1307 b1307 0 10
X1307 56 g1307 8 b1307 NMOSWRAP
VG1308 g1308 0 0.6000000000000000
RB1308 b1308 0 10
X1308 56 g1308 9 b1308 NMOSWRAP
VG1309 g1309 0 0.6000000000000000
RB1309 b1309 0 10
X1309 56 g1309 9 b1309 NMOSWRAP
VG1310 g1310 0 0.6000000000000000
RB1310 b1310 0 10
X1310 56 g1310 9 b1310 NMOSWRAP
VG1311 g1311 0 0.6000000000000000
RB1311 b1311 0 10
X1311 56 g1311 10 b1311 NMOSWRAP
VG1312 g1312 0 0.6000000000000000
RB1312 b1312 0 10
X1312 56 g1312 10 b1312 NMOSWRAP
VG1313 g1313 0 0.6000000000000000
RB1313 b1313 0 10
X1313 56 g1313 10 b1313 NMOSWRAP
VG1314 g1314 0 0.6000000000000000
RB1314 b1314 0 10
X1314 56 g1314 11 b1314 NMOSWRAP
VG1315 g1315 0 0.6000000000000000
RB1315 b1315 0 10
X1315 56 g1315 11 b1315 NMOSWRAP
VG1316 g1316 0 0.6000000000000000
RB1316 b1316 0 10
X1316 56 g1316 11 b1316 NMOSWRAP
VG1317 g1317 0 0.6000000000000000
RB1317 b1317 0 10
X1317 56 g1317 12 b1317 NMOSWRAP
VG1318 g1318 0 0.6000000000000000
RB1318 b1318 0 10
X1318 56 g1318 12 b1318 NMOSWRAP
VG1319 g1319 0 0.6000000000000000
RB1319 b1319 0 10
X1319 56 g1319 12 b1319 NMOSWRAP
VG1320 g1320 0 0.6000000000000000
RB1320 b1320 0 10
X1320 57 g1320 3 b1320 NMOSWRAP
VG1321 g1321 0 0.6000000000000000
RB1321 b1321 0 10
X1321 57 g1321 3 b1321 NMOSWRAP
VG1322 g1322 0 0.6000000000000000
RB1322 b1322 0 10
X1322 57 g1322 3 b1322 NMOSWRAP
VG1323 g1323 0 0.6000000000000000
RB1323 b1323 0 10
X1323 57 g1323 4 b1323 NMOSWRAP
VG1324 g1324 0 0.6000000000000000
RB1324 b1324 0 10
X1324 57 g1324 4 b1324 NMOSWRAP
VG1325 g1325 0 0.6000000000000000
RB1325 b1325 0 10
X1325 57 g1325 4 b1325 NMOSWRAP
VG1326 g1326 0 0.6000000000000000
RB1326 b1326 0 10
X1326 57 g1326 5 b1326 NMOSWRAP
VG1327 g1327 0 0.6000000000000000
RB1327 b1327 0 10
X1327 57 g1327 5 b1327 NMOSWRAP
VG1328 g1328 0 0.6000000000000000
RB1328 b1328 0 10
X1328 57 g1328 5 b1328 NMOSWRAP
VG1329 g1329 0 0.6000000000000000
RB1329 b1329 0 10
X1329 57 g1329 6 b1329 NMOSWRAP
VG1330 g1330 0 0.6000000000000000
RB1330 b1330 0 10
X1330 57 g1330 6 b1330 NMOSWRAP
VG1331 g1331 0 0.6000000000000000
RB1331 b1331 0 10
X1331 57 g1331 6 b1331 NMOSWRAP
VG1332 g1332 0 0.6000000000000000
RB1332 b1332 0 10
X1332 57 g1332 7 b1332 NMOSWRAP
VG1333 g1333 0 0.6000000000000000
RB1333 b1333 0 10
X1333 57 g1333 7 b1333 NMOSWRAP
VG1334 g1334 0 0.6000000000000000
RB1334 b1334 0 10
X1334 57 g1334 7 b1334 NMOSWRAP
VG1335 g1335 0 0.6000000000000000
RB1335 b1335 0 10
X1335 57 g1335 8 b1335 NMOSWRAP
VG1336 g1336 0 0.6000000000000000
RB1336 b1336 0 10
X1336 57 g1336 8 b1336 NMOSWRAP
VG1337 g1337 0 0.6000000000000000
RB1337 b1337 0 10
X1337 57 g1337 8 b1337 NMOSWRAP
VG1338 g1338 0 0.6000000000000000
RB1338 b1338 0 10
X1338 57 g1338 9 b1338 NMOSWRAP
VG1339 g1339 0 0.6000000000000000
RB1339 b1339 0 10
X1339 57 g1339 9 b1339 NMOSWRAP
VG1340 g1340 0 0.6000000000000000
RB1340 b1340 0 10
X1340 57 g1340 9 b1340 NMOSWRAP
VG1341 g1341 0 0.6000000000000000
RB1341 b1341 0 10
X1341 57 g1341 10 b1341 NMOSWRAP
VG1342 g1342 0 0.6000000000000000
RB1342 b1342 0 10
X1342 57 g1342 10 b1342 NMOSWRAP
VG1343 g1343 0 0.6000000000000000
RB1343 b1343 0 10
X1343 57 g1343 10 b1343 NMOSWRAP
VG1344 g1344 0 0.6000000000000000
RB1344 b1344 0 10
X1344 57 g1344 11 b1344 NMOSWRAP
VG1345 g1345 0 0.6000000000000000
RB1345 b1345 0 10
X1345 57 g1345 11 b1345 NMOSWRAP
VG1346 g1346 0 0.6000000000000000
RB1346 b1346 0 10
X1346 57 g1346 11 b1346 NMOSWRAP
VG1347 g1347 0 0.6000000000000000
RB1347 b1347 0 10
X1347 57 g1347 12 b1347 NMOSWRAP
VG1348 g1348 0 0.6000000000000000
RB1348 b1348 0 10
X1348 57 g1348 12 b1348 NMOSWRAP
VG1349 g1349 0 0.6000000000000000
RB1349 b1349 0 10
X1349 57 g1349 12 b1349 NMOSWRAP
VG1350 g1350 0 0.6000000000000000
RB1350 b1350 0 10
X1350 58 g1350 3 b1350 NMOSWRAP
VG1351 g1351 0 0.6000000000000000
RB1351 b1351 0 10
X1351 58 g1351 3 b1351 NMOSWRAP
VG1352 g1352 0 0.6000000000000000
RB1352 b1352 0 10
X1352 58 g1352 3 b1352 NMOSWRAP
VG1353 g1353 0 0.6000000000000000
RB1353 b1353 0 10
X1353 58 g1353 4 b1353 NMOSWRAP
VG1354 g1354 0 0.6000000000000000
RB1354 b1354 0 10
X1354 58 g1354 4 b1354 NMOSWRAP
VG1355 g1355 0 0.6000000000000000
RB1355 b1355 0 10
X1355 58 g1355 4 b1355 NMOSWRAP
VG1356 g1356 0 0.6000000000000000
RB1356 b1356 0 10
X1356 58 g1356 5 b1356 NMOSWRAP
VG1357 g1357 0 0.6000000000000000
RB1357 b1357 0 10
X1357 58 g1357 5 b1357 NMOSWRAP
VG1358 g1358 0 0.6000000000000000
RB1358 b1358 0 10
X1358 58 g1358 5 b1358 NMOSWRAP
VG1359 g1359 0 0.6000000000000000
RB1359 b1359 0 10
X1359 58 g1359 6 b1359 NMOSWRAP
VG1360 g1360 0 0.6000000000000000
RB1360 b1360 0 10
X1360 58 g1360 6 b1360 NMOSWRAP
VG1361 g1361 0 0.6000000000000000
RB1361 b1361 0 10
X1361 58 g1361 6 b1361 NMOSWRAP
VG1362 g1362 0 0.6000000000000000
RB1362 b1362 0 10
X1362 58 g1362 7 b1362 NMOSWRAP
VG1363 g1363 0 0.6000000000000000
RB1363 b1363 0 10
X1363 58 g1363 7 b1363 NMOSWRAP
VG1364 g1364 0 0.6000000000000000
RB1364 b1364 0 10
X1364 58 g1364 7 b1364 NMOSWRAP
VG1365 g1365 0 0.6000000000000000
RB1365 b1365 0 10
X1365 58 g1365 8 b1365 NMOSWRAP
VG1366 g1366 0 0.6000000000000000
RB1366 b1366 0 10
X1366 58 g1366 8 b1366 NMOSWRAP
VG1367 g1367 0 0.6000000000000000
RB1367 b1367 0 10
X1367 58 g1367 8 b1367 NMOSWRAP
VG1368 g1368 0 0.6000000000000000
RB1368 b1368 0 10
X1368 58 g1368 9 b1368 NMOSWRAP
VG1369 g1369 0 0.6000000000000000
RB1369 b1369 0 10
X1369 58 g1369 9 b1369 NMOSWRAP
VG1370 g1370 0 0.6000000000000000
RB1370 b1370 0 10
X1370 58 g1370 9 b1370 NMOSWRAP
VG1371 g1371 0 0.6000000000000000
RB1371 b1371 0 10
X1371 58 g1371 10 b1371 NMOSWRAP
VG1372 g1372 0 0.6000000000000000
RB1372 b1372 0 10
X1372 58 g1372 10 b1372 NMOSWRAP
VG1373 g1373 0 0.6000000000000000
RB1373 b1373 0 10
X1373 58 g1373 10 b1373 NMOSWRAP
VG1374 g1374 0 0.6000000000000000
RB1374 b1374 0 10
X1374 58 g1374 11 b1374 NMOSWRAP
VG1375 g1375 0 0.6000000000000000
RB1375 b1375 0 10
X1375 58 g1375 11 b1375 NMOSWRAP
VG1376 g1376 0 0.6000000000000000
RB1376 b1376 0 10
X1376 58 g1376 11 b1376 NMOSWRAP
VG1377 g1377 0 0.6000000000000000
RB1377 b1377 0 10
X1377 58 g1377 12 b1377 NMOSWRAP
VG1378 g1378 0 0.6000000000000000
RB1378 b1378 0 10
X1378 58 g1378 12 b1378 NMOSWRAP
VG1379 g1379 0 0.6000000000000000
RB1379 b1379 0 10
X1379 58 g1379 12 b1379 NMOSWRAP
VG1380 g1380 0 0.6000000000000000
RB1380 b1380 0 10
X1380 59 g1380 3 b1380 NMOSWRAP
VG1381 g1381 0 0.6000000000000000
RB1381 b1381 0 10
X1381 59 g1381 3 b1381 NMOSWRAP
VG1382 g1382 0 0.6000000000000000
RB1382 b1382 0 10
X1382 59 g1382 3 b1382 NMOSWRAP
VG1383 g1383 0 0.6000000000000000
RB1383 b1383 0 10
X1383 59 g1383 4 b1383 NMOSWRAP
VG1384 g1384 0 0.6000000000000000
RB1384 b1384 0 10
X1384 59 g1384 4 b1384 NMOSWRAP
VG1385 g1385 0 0.6000000000000000
RB1385 b1385 0 10
X1385 59 g1385 4 b1385 NMOSWRAP
VG1386 g1386 0 0.6000000000000000
RB1386 b1386 0 10
X1386 59 g1386 5 b1386 NMOSWRAP
VG1387 g1387 0 0.6000000000000000
RB1387 b1387 0 10
X1387 59 g1387 5 b1387 NMOSWRAP
VG1388 g1388 0 0.6000000000000000
RB1388 b1388 0 10
X1388 59 g1388 5 b1388 NMOSWRAP
VG1389 g1389 0 0.6000000000000000
RB1389 b1389 0 10
X1389 59 g1389 6 b1389 NMOSWRAP
VG1390 g1390 0 0.6000000000000000
RB1390 b1390 0 10
X1390 59 g1390 6 b1390 NMOSWRAP
VG1391 g1391 0 0.6000000000000000
RB1391 b1391 0 10
X1391 59 g1391 6 b1391 NMOSWRAP
VG1392 g1392 0 0.6000000000000000
RB1392 b1392 0 10
X1392 59 g1392 7 b1392 NMOSWRAP
VG1393 g1393 0 0.6000000000000000
RB1393 b1393 0 10
X1393 59 g1393 7 b1393 NMOSWRAP
VG1394 g1394 0 0.6000000000000000
RB1394 b1394 0 10
X1394 59 g1394 7 b1394 NMOSWRAP
VG1395 g1395 0 0.6000000000000000
RB1395 b1395 0 10
X1395 59 g1395 8 b1395 NMOSWRAP
VG1396 g1396 0 0.6000000000000000
RB1396 b1396 0 10
X1396 59 g1396 8 b1396 NMOSWRAP
VG1397 g1397 0 0.6000000000000000
RB1397 b1397 0 10
X1397 59 g1397 8 b1397 NMOSWRAP
VG1398 g1398 0 0.6000000000000000
RB1398 b1398 0 10
X1398 59 g1398 9 b1398 NMOSWRAP
VG1399 g1399 0 0.6000000000000000
RB1399 b1399 0 10
X1399 59 g1399 9 b1399 NMOSWRAP
VG1400 g1400 0 0.6000000000000000
RB1400 b1400 0 10
X1400 59 g1400 9 b1400 NMOSWRAP
VG1401 g1401 0 0.6000000000000000
RB1401 b1401 0 10
X1401 59 g1401 10 b1401 NMOSWRAP
VG1402 g1402 0 0.6000000000000000
RB1402 b1402 0 10
X1402 59 g1402 10 b1402 NMOSWRAP
VG1403 g1403 0 0.6000000000000000
RB1403 b1403 0 10
X1403 59 g1403 10 b1403 NMOSWRAP
VG1404 g1404 0 0.6000000000000000
RB1404 b1404 0 10
X1404 59 g1404 11 b1404 NMOSWRAP
VG1405 g1405 0 0.6000000000000000
RB1405 b1405 0 10
X1405 59 g1405 11 b1405 NMOSWRAP
VG1406 g1406 0 0.6000000000000000
RB1406 b1406 0 10
X1406 59 g1406 11 b1406 NMOSWRAP
VG1407 g1407 0 0.6000000000000000
RB1407 b1407 0 10
X1407 59 g1407 12 b1407 NMOSWRAP
VG1408 g1408 0 0.6000000000000000
RB1408 b1408 0 10
X1408 59 g1408 12 b1408 NMOSWRAP
VG1409 g1409 0 0.6000000000000000
RB1409 b1409 0 10
X1409 59 g1409 12 b1409 NMOSWRAP
VG1410 g1410 0 0.6000000000000000
RB1410 b1410 0 10
X1410 60 g1410 3 b1410 NMOSWRAP
VG1411 g1411 0 0.6000000000000000
RB1411 b1411 0 10
X1411 60 g1411 3 b1411 NMOSWRAP
VG1412 g1412 0 0.6000000000000000
RB1412 b1412 0 10
X1412 60 g1412 3 b1412 NMOSWRAP
VG1413 g1413 0 0.6000000000000000
RB1413 b1413 0 10
X1413 60 g1413 4 b1413 NMOSWRAP
VG1414 g1414 0 0.6000000000000000
RB1414 b1414 0 10
X1414 60 g1414 4 b1414 NMOSWRAP
VG1415 g1415 0 0.6000000000000000
RB1415 b1415 0 10
X1415 60 g1415 4 b1415 NMOSWRAP
VG1416 g1416 0 0.6000000000000000
RB1416 b1416 0 10
X1416 60 g1416 5 b1416 NMOSWRAP
VG1417 g1417 0 0.6000000000000000
RB1417 b1417 0 10
X1417 60 g1417 5 b1417 NMOSWRAP
VG1418 g1418 0 0.6000000000000000
RB1418 b1418 0 10
X1418 60 g1418 5 b1418 NMOSWRAP
VG1419 g1419 0 0.6000000000000000
RB1419 b1419 0 10
X1419 60 g1419 6 b1419 NMOSWRAP
VG1420 g1420 0 0.6000000000000000
RB1420 b1420 0 10
X1420 60 g1420 6 b1420 NMOSWRAP
VG1421 g1421 0 0.6000000000000000
RB1421 b1421 0 10
X1421 60 g1421 6 b1421 NMOSWRAP
VG1422 g1422 0 0.6000000000000000
RB1422 b1422 0 10
X1422 60 g1422 7 b1422 NMOSWRAP
VG1423 g1423 0 0.6000000000000000
RB1423 b1423 0 10
X1423 60 g1423 7 b1423 NMOSWRAP
VG1424 g1424 0 0.6000000000000000
RB1424 b1424 0 10
X1424 60 g1424 7 b1424 NMOSWRAP
VG1425 g1425 0 0.6000000000000000
RB1425 b1425 0 10
X1425 60 g1425 8 b1425 NMOSWRAP
VG1426 g1426 0 0.6000000000000000
RB1426 b1426 0 10
X1426 60 g1426 8 b1426 NMOSWRAP
VG1427 g1427 0 0.6000000000000000
RB1427 b1427 0 10
X1427 60 g1427 8 b1427 NMOSWRAP
VG1428 g1428 0 0.6000000000000000
RB1428 b1428 0 10
X1428 60 g1428 9 b1428 NMOSWRAP
VG1429 g1429 0 0.6000000000000000
RB1429 b1429 0 10
X1429 60 g1429 9 b1429 NMOSWRAP
VG1430 g1430 0 0.6000000000000000
RB1430 b1430 0 10
X1430 60 g1430 9 b1430 NMOSWRAP
VG1431 g1431 0 0.6000000000000000
RB1431 b1431 0 10
X1431 60 g1431 10 b1431 NMOSWRAP
VG1432 g1432 0 0.6000000000000000
RB1432 b1432 0 10
X1432 60 g1432 10 b1432 NMOSWRAP
VG1433 g1433 0 0.6000000000000000
RB1433 b1433 0 10
X1433 60 g1433 10 b1433 NMOSWRAP
VG1434 g1434 0 0.6000000000000000
RB1434 b1434 0 10
X1434 60 g1434 11 b1434 NMOSWRAP
VG1435 g1435 0 0.6000000000000000
RB1435 b1435 0 10
X1435 60 g1435 11 b1435 NMOSWRAP
VG1436 g1436 0 0.6000000000000000
RB1436 b1436 0 10
X1436 60 g1436 11 b1436 NMOSWRAP
VG1437 g1437 0 0.6000000000000000
RB1437 b1437 0 10
X1437 60 g1437 12 b1437 NMOSWRAP
VG1438 g1438 0 0.6000000000000000
RB1438 b1438 0 10
X1438 60 g1438 12 b1438 NMOSWRAP
VG1439 g1439 0 0.6000000000000000
RB1439 b1439 0 10
X1439 60 g1439 12 b1439 NMOSWRAP
VG1440 g1440 0 0.6000000000000000
RB1440 b1440 0 10
X1440 61 g1440 3 b1440 NMOSWRAP
VG1441 g1441 0 0.6000000000000000
RB1441 b1441 0 10
X1441 61 g1441 3 b1441 NMOSWRAP
VG1442 g1442 0 0.6000000000000000
RB1442 b1442 0 10
X1442 61 g1442 3 b1442 NMOSWRAP
VG1443 g1443 0 0.6000000000000000
RB1443 b1443 0 10
X1443 61 g1443 4 b1443 NMOSWRAP
VG1444 g1444 0 0.6000000000000000
RB1444 b1444 0 10
X1444 61 g1444 4 b1444 NMOSWRAP
VG1445 g1445 0 0.6000000000000000
RB1445 b1445 0 10
X1445 61 g1445 4 b1445 NMOSWRAP
VG1446 g1446 0 0.6000000000000000
RB1446 b1446 0 10
X1446 61 g1446 5 b1446 NMOSWRAP
VG1447 g1447 0 0.6000000000000000
RB1447 b1447 0 10
X1447 61 g1447 5 b1447 NMOSWRAP
VG1448 g1448 0 0.6000000000000000
RB1448 b1448 0 10
X1448 61 g1448 5 b1448 NMOSWRAP
VG1449 g1449 0 0.6000000000000000
RB1449 b1449 0 10
X1449 61 g1449 6 b1449 NMOSWRAP
VG1450 g1450 0 0.6000000000000000
RB1450 b1450 0 10
X1450 61 g1450 6 b1450 NMOSWRAP
VG1451 g1451 0 0.6000000000000000
RB1451 b1451 0 10
X1451 61 g1451 6 b1451 NMOSWRAP
VG1452 g1452 0 0.6000000000000000
RB1452 b1452 0 10
X1452 61 g1452 7 b1452 NMOSWRAP
VG1453 g1453 0 0.6000000000000000
RB1453 b1453 0 10
X1453 61 g1453 7 b1453 NMOSWRAP
VG1454 g1454 0 0.6000000000000000
RB1454 b1454 0 10
X1454 61 g1454 7 b1454 NMOSWRAP
VG1455 g1455 0 0.6000000000000000
RB1455 b1455 0 10
X1455 61 g1455 8 b1455 NMOSWRAP
VG1456 g1456 0 0.6000000000000000
RB1456 b1456 0 10
X1456 61 g1456 8 b1456 NMOSWRAP
VG1457 g1457 0 0.6000000000000000
RB1457 b1457 0 10
X1457 61 g1457 8 b1457 NMOSWRAP
VG1458 g1458 0 0.6000000000000000
RB1458 b1458 0 10
X1458 61 g1458 9 b1458 NMOSWRAP
VG1459 g1459 0 0.6000000000000000
RB1459 b1459 0 10
X1459 61 g1459 9 b1459 NMOSWRAP
VG1460 g1460 0 0.6000000000000000
RB1460 b1460 0 10
X1460 61 g1460 9 b1460 NMOSWRAP
VG1461 g1461 0 0.6000000000000000
RB1461 b1461 0 10
X1461 61 g1461 10 b1461 NMOSWRAP
VG1462 g1462 0 0.6000000000000000
RB1462 b1462 0 10
X1462 61 g1462 10 b1462 NMOSWRAP
VG1463 g1463 0 0.6000000000000000
RB1463 b1463 0 10
X1463 61 g1463 10 b1463 NMOSWRAP
VG1464 g1464 0 0.6000000000000000
RB1464 b1464 0 10
X1464 61 g1464 11 b1464 NMOSWRAP
VG1465 g1465 0 0.6000000000000000
RB1465 b1465 0 10
X1465 61 g1465 11 b1465 NMOSWRAP
VG1466 g1466 0 0.6000000000000000
RB1466 b1466 0 10
X1466 61 g1466 11 b1466 NMOSWRAP
VG1467 g1467 0 0.6000000000000000
RB1467 b1467 0 10
X1467 61 g1467 12 b1467 NMOSWRAP
VG1468 g1468 0 0.6000000000000000
RB1468 b1468 0 10
X1468 61 g1468 12 b1468 NMOSWRAP
VG1469 g1469 0 0.6000000000000000
RB1469 b1469 0 10
X1469 61 g1469 12 b1469 NMOSWRAP
VG1470 g1470 0 0.6000000000000000
RB1470 b1470 0 10
X1470 62 g1470 3 b1470 NMOSWRAP
VG1471 g1471 0 0.6000000000000000
RB1471 b1471 0 10
X1471 62 g1471 3 b1471 NMOSWRAP
VG1472 g1472 0 0.6000000000000000
RB1472 b1472 0 10
X1472 62 g1472 3 b1472 NMOSWRAP
VG1473 g1473 0 0.6000000000000000
RB1473 b1473 0 10
X1473 62 g1473 4 b1473 NMOSWRAP
VG1474 g1474 0 0.6000000000000000
RB1474 b1474 0 10
X1474 62 g1474 4 b1474 NMOSWRAP
VG1475 g1475 0 0.6000000000000000
RB1475 b1475 0 10
X1475 62 g1475 4 b1475 NMOSWRAP
VG1476 g1476 0 0.6000000000000000
RB1476 b1476 0 10
X1476 62 g1476 5 b1476 NMOSWRAP
VG1477 g1477 0 0.6000000000000000
RB1477 b1477 0 10
X1477 62 g1477 5 b1477 NMOSWRAP
VG1478 g1478 0 0.6000000000000000
RB1478 b1478 0 10
X1478 62 g1478 5 b1478 NMOSWRAP
VG1479 g1479 0 0.6000000000000000
RB1479 b1479 0 10
X1479 62 g1479 6 b1479 NMOSWRAP
VG1480 g1480 0 0.6000000000000000
RB1480 b1480 0 10
X1480 62 g1480 6 b1480 NMOSWRAP
VG1481 g1481 0 0.6000000000000000
RB1481 b1481 0 10
X1481 62 g1481 6 b1481 NMOSWRAP
VG1482 g1482 0 0.6000000000000000
RB1482 b1482 0 10
X1482 62 g1482 7 b1482 NMOSWRAP
VG1483 g1483 0 0.6000000000000000
RB1483 b1483 0 10
X1483 62 g1483 7 b1483 NMOSWRAP
VG1484 g1484 0 0.6000000000000000
RB1484 b1484 0 10
X1484 62 g1484 7 b1484 NMOSWRAP
VG1485 g1485 0 0.6000000000000000
RB1485 b1485 0 10
X1485 62 g1485 8 b1485 NMOSWRAP
VG1486 g1486 0 0.6000000000000000
RB1486 b1486 0 10
X1486 62 g1486 8 b1486 NMOSWRAP
VG1487 g1487 0 0.6000000000000000
RB1487 b1487 0 10
X1487 62 g1487 8 b1487 NMOSWRAP
VG1488 g1488 0 0.6000000000000000
RB1488 b1488 0 10
X1488 62 g1488 9 b1488 NMOSWRAP
VG1489 g1489 0 0.6000000000000000
RB1489 b1489 0 10
X1489 62 g1489 9 b1489 NMOSWRAP
VG1490 g1490 0 0.6000000000000000
RB1490 b1490 0 10
X1490 62 g1490 9 b1490 NMOSWRAP
VG1491 g1491 0 0.6000000000000000
RB1491 b1491 0 10
X1491 62 g1491 10 b1491 NMOSWRAP
VG1492 g1492 0 0.6000000000000000
RB1492 b1492 0 10
X1492 62 g1492 10 b1492 NMOSWRAP
VG1493 g1493 0 0.6000000000000000
RB1493 b1493 0 10
X1493 62 g1493 10 b1493 NMOSWRAP
VG1494 g1494 0 0.6000000000000000
RB1494 b1494 0 10
X1494 62 g1494 11 b1494 NMOSWRAP
VG1495 g1495 0 0.6000000000000000
RB1495 b1495 0 10
X1495 62 g1495 11 b1495 NMOSWRAP
VG1496 g1496 0 0.6000000000000000
RB1496 b1496 0 10
X1496 62 g1496 11 b1496 NMOSWRAP
VG1497 g1497 0 0.6000000000000000
RB1497 b1497 0 10
X1497 62 g1497 12 b1497 NMOSWRAP
VG1498 g1498 0 0.6000000000000000
RB1498 b1498 0 10
X1498 62 g1498 12 b1498 NMOSWRAP
VG1499 g1499 0 0.6000000000000000
RB1499 b1499 0 10
X1499 62 g1499 12 b1499 NMOSWRAP
VG1500 g1500 0 0.6000000000000000
RB1500 b1500 0 10
X1500 63 g1500 3 b1500 NMOSWRAP
VG1501 g1501 0 0.6000000000000000
RB1501 b1501 0 10
X1501 63 g1501 3 b1501 NMOSWRAP
VG1502 g1502 0 0.6000000000000000
RB1502 b1502 0 10
X1502 63 g1502 3 b1502 NMOSWRAP
VG1503 g1503 0 0.6000000000000000
RB1503 b1503 0 10
X1503 63 g1503 4 b1503 NMOSWRAP
VG1504 g1504 0 0.6000000000000000
RB1504 b1504 0 10
X1504 63 g1504 4 b1504 NMOSWRAP
VG1505 g1505 0 0.6000000000000000
RB1505 b1505 0 10
X1505 63 g1505 4 b1505 NMOSWRAP
VG1506 g1506 0 0.6000000000000000
RB1506 b1506 0 10
X1506 63 g1506 5 b1506 NMOSWRAP
VG1507 g1507 0 0.6000000000000000
RB1507 b1507 0 10
X1507 63 g1507 5 b1507 NMOSWRAP
VG1508 g1508 0 0.6000000000000000
RB1508 b1508 0 10
X1508 63 g1508 5 b1508 NMOSWRAP
VG1509 g1509 0 0.6000000000000000
RB1509 b1509 0 10
X1509 63 g1509 6 b1509 NMOSWRAP
VG1510 g1510 0 0.6000000000000000
RB1510 b1510 0 10
X1510 63 g1510 6 b1510 NMOSWRAP
VG1511 g1511 0 0.6000000000000000
RB1511 b1511 0 10
X1511 63 g1511 6 b1511 NMOSWRAP
VG1512 g1512 0 0.6000000000000000
RB1512 b1512 0 10
X1512 63 g1512 7 b1512 NMOSWRAP
VG1513 g1513 0 0.6000000000000000
RB1513 b1513 0 10
X1513 63 g1513 7 b1513 NMOSWRAP
VG1514 g1514 0 0.6000000000000000
RB1514 b1514 0 10
X1514 63 g1514 7 b1514 NMOSWRAP
VG1515 g1515 0 0.6000000000000000
RB1515 b1515 0 10
X1515 63 g1515 8 b1515 NMOSWRAP
VG1516 g1516 0 0.6000000000000000
RB1516 b1516 0 10
X1516 63 g1516 8 b1516 NMOSWRAP
VG1517 g1517 0 0.6000000000000000
RB1517 b1517 0 10
X1517 63 g1517 8 b1517 NMOSWRAP
VG1518 g1518 0 0.6000000000000000
RB1518 b1518 0 10
X1518 63 g1518 9 b1518 NMOSWRAP
VG1519 g1519 0 0.6000000000000000
RB1519 b1519 0 10
X1519 63 g1519 9 b1519 NMOSWRAP
VG1520 g1520 0 0.6000000000000000
RB1520 b1520 0 10
X1520 63 g1520 9 b1520 NMOSWRAP
VG1521 g1521 0 0.6000000000000000
RB1521 b1521 0 10
X1521 63 g1521 10 b1521 NMOSWRAP
VG1522 g1522 0 0.6000000000000000
RB1522 b1522 0 10
X1522 63 g1522 10 b1522 NMOSWRAP
VG1523 g1523 0 0.6000000000000000
RB1523 b1523 0 10
X1523 63 g1523 10 b1523 NMOSWRAP
VG1524 g1524 0 0.6000000000000000
RB1524 b1524 0 10
X1524 63 g1524 11 b1524 NMOSWRAP
VG1525 g1525 0 0.6000000000000000
RB1525 b1525 0 10
X1525 63 g1525 11 b1525 NMOSWRAP
VG1526 g1526 0 0.6000000000000000
RB1526 b1526 0 10
X1526 63 g1526 11 b1526 NMOSWRAP
VG1527 g1527 0 0.6000000000000000
RB1527 b1527 0 10
X1527 63 g1527 12 b1527 NMOSWRAP
VG1528 g1528 0 0.6000000000000000
RB1528 b1528 0 10
X1528 63 g1528 12 b1528 NMOSWRAP
VG1529 g1529 0 0.6000000000000000
RB1529 b1529 0 10
X1529 63 g1529 12 b1529 NMOSWRAP
VG1530 g1530 0 0.6000000000000000
RB1530 b1530 0 10
X1530 64 g1530 3 b1530 NMOSWRAP
VG1531 g1531 0 0.6000000000000000
RB1531 b1531 0 10
X1531 64 g1531 3 b1531 NMOSWRAP
VG1532 g1532 0 0.6000000000000000
RB1532 b1532 0 10
X1532 64 g1532 3 b1532 NMOSWRAP
VG1533 g1533 0 0.6000000000000000
RB1533 b1533 0 10
X1533 64 g1533 4 b1533 NMOSWRAP
VG1534 g1534 0 0.6000000000000000
RB1534 b1534 0 10
X1534 64 g1534 4 b1534 NMOSWRAP
VG1535 g1535 0 0.6000000000000000
RB1535 b1535 0 10
X1535 64 g1535 4 b1535 NMOSWRAP
VG1536 g1536 0 0.6000000000000000
RB1536 b1536 0 10
X1536 64 g1536 5 b1536 NMOSWRAP
VG1537 g1537 0 0.6000000000000000
RB1537 b1537 0 10
X1537 64 g1537 5 b1537 NMOSWRAP
VG1538 g1538 0 0.6000000000000000
RB1538 b1538 0 10
X1538 64 g1538 5 b1538 NMOSWRAP
VG1539 g1539 0 0.6000000000000000
RB1539 b1539 0 10
X1539 64 g1539 6 b1539 NMOSWRAP
VG1540 g1540 0 0.6000000000000000
RB1540 b1540 0 10
X1540 64 g1540 6 b1540 NMOSWRAP
VG1541 g1541 0 0.6000000000000000
RB1541 b1541 0 10
X1541 64 g1541 6 b1541 NMOSWRAP
VG1542 g1542 0 0.6000000000000000
RB1542 b1542 0 10
X1542 64 g1542 7 b1542 NMOSWRAP
VG1543 g1543 0 0.6000000000000000
RB1543 b1543 0 10
X1543 64 g1543 7 b1543 NMOSWRAP
VG1544 g1544 0 0.6000000000000000
RB1544 b1544 0 10
X1544 64 g1544 7 b1544 NMOSWRAP
VG1545 g1545 0 0.6000000000000000
RB1545 b1545 0 10
X1545 64 g1545 8 b1545 NMOSWRAP
VG1546 g1546 0 0.6000000000000000
RB1546 b1546 0 10
X1546 64 g1546 8 b1546 NMOSWRAP
VG1547 g1547 0 0.6000000000000000
RB1547 b1547 0 10
X1547 64 g1547 8 b1547 NMOSWRAP
VG1548 g1548 0 0.6000000000000000
RB1548 b1548 0 10
X1548 64 g1548 9 b1548 NMOSWRAP
VG1549 g1549 0 0.6000000000000000
RB1549 b1549 0 10
X1549 64 g1549 9 b1549 NMOSWRAP
VG1550 g1550 0 0.6000000000000000
RB1550 b1550 0 10
X1550 64 g1550 9 b1550 NMOSWRAP
VG1551 g1551 0 0.6000000000000000
RB1551 b1551 0 10
X1551 64 g1551 10 b1551 NMOSWRAP
VG1552 g1552 0 0.6000000000000000
RB1552 b1552 0 10
X1552 64 g1552 10 b1552 NMOSWRAP
VG1553 g1553 0 0.6000000000000000
RB1553 b1553 0 10
X1553 64 g1553 10 b1553 NMOSWRAP
VG1554 g1554 0 0.6000000000000000
RB1554 b1554 0 10
X1554 64 g1554 11 b1554 NMOSWRAP
VG1555 g1555 0 0.6000000000000000
RB1555 b1555 0 10
X1555 64 g1555 11 b1555 NMOSWRAP
VG1556 g1556 0 0.6000000000000000
RB1556 b1556 0 10
X1556 64 g1556 11 b1556 NMOSWRAP
VG1557 g1557 0 0.6000000000000000
RB1557 b1557 0 10
X1557 64 g1557 12 b1557 NMOSWRAP
VG1558 g1558 0 0.6000000000000000
RB1558 b1558 0 10
X1558 64 g1558 12 b1558 NMOSWRAP
VG1559 g1559 0 0.6000000000000000
RB1559 b1559 0 10
X1559 64 g1559 12 b1559 NMOSWRAP
VG1560 g1560 0 0.6000000000000000
RB1560 b1560 0 10
X1560 65 g1560 3 b1560 NMOSWRAP
VG1561 g1561 0 0.6000000000000000
RB1561 b1561 0 10
X1561 65 g1561 3 b1561 NMOSWRAP
VG1562 g1562 0 0.6000000000000000
RB1562 b1562 0 10
X1562 65 g1562 3 b1562 NMOSWRAP
VG1563 g1563 0 0.6000000000000000
RB1563 b1563 0 10
X1563 65 g1563 4 b1563 NMOSWRAP
VG1564 g1564 0 0.6000000000000000
RB1564 b1564 0 10
X1564 65 g1564 4 b1564 NMOSWRAP
VG1565 g1565 0 0.6000000000000000
RB1565 b1565 0 10
X1565 65 g1565 4 b1565 NMOSWRAP
VG1566 g1566 0 0.6000000000000000
RB1566 b1566 0 10
X1566 65 g1566 5 b1566 NMOSWRAP
VG1567 g1567 0 0.6000000000000000
RB1567 b1567 0 10
X1567 65 g1567 5 b1567 NMOSWRAP
VG1568 g1568 0 0.6000000000000000
RB1568 b1568 0 10
X1568 65 g1568 5 b1568 NMOSWRAP
VG1569 g1569 0 0.6000000000000000
RB1569 b1569 0 10
X1569 65 g1569 6 b1569 NMOSWRAP
VG1570 g1570 0 0.6000000000000000
RB1570 b1570 0 10
X1570 65 g1570 6 b1570 NMOSWRAP
VG1571 g1571 0 0.6000000000000000
RB1571 b1571 0 10
X1571 65 g1571 6 b1571 NMOSWRAP
VG1572 g1572 0 0.6000000000000000
RB1572 b1572 0 10
X1572 65 g1572 7 b1572 NMOSWRAP
VG1573 g1573 0 0.6000000000000000
RB1573 b1573 0 10
X1573 65 g1573 7 b1573 NMOSWRAP
VG1574 g1574 0 0.6000000000000000
RB1574 b1574 0 10
X1574 65 g1574 7 b1574 NMOSWRAP
VG1575 g1575 0 0.6000000000000000
RB1575 b1575 0 10
X1575 65 g1575 8 b1575 NMOSWRAP
VG1576 g1576 0 0.6000000000000000
RB1576 b1576 0 10
X1576 65 g1576 8 b1576 NMOSWRAP
VG1577 g1577 0 0.6000000000000000
RB1577 b1577 0 10
X1577 65 g1577 8 b1577 NMOSWRAP
VG1578 g1578 0 0.6000000000000000
RB1578 b1578 0 10
X1578 65 g1578 9 b1578 NMOSWRAP
VG1579 g1579 0 0.6000000000000000
RB1579 b1579 0 10
X1579 65 g1579 9 b1579 NMOSWRAP
VG1580 g1580 0 0.6000000000000000
RB1580 b1580 0 10
X1580 65 g1580 9 b1580 NMOSWRAP
VG1581 g1581 0 0.6000000000000000
RB1581 b1581 0 10
X1581 65 g1581 10 b1581 NMOSWRAP
VG1582 g1582 0 0.6000000000000000
RB1582 b1582 0 10
X1582 65 g1582 10 b1582 NMOSWRAP
VG1583 g1583 0 0.6000000000000000
RB1583 b1583 0 10
X1583 65 g1583 10 b1583 NMOSWRAP
VG1584 g1584 0 0.6000000000000000
RB1584 b1584 0 10
X1584 65 g1584 11 b1584 NMOSWRAP
VG1585 g1585 0 0.6000000000000000
RB1585 b1585 0 10
X1585 65 g1585 11 b1585 NMOSWRAP
VG1586 g1586 0 0.6000000000000000
RB1586 b1586 0 10
X1586 65 g1586 11 b1586 NMOSWRAP
VG1587 g1587 0 0.6000000000000000
RB1587 b1587 0 10
X1587 65 g1587 12 b1587 NMOSWRAP
VG1588 g1588 0 0.6000000000000000
RB1588 b1588 0 10
X1588 65 g1588 12 b1588 NMOSWRAP
VG1589 g1589 0 0.6000000000000000
RB1589 b1589 0 10
X1589 65 g1589 12 b1589 NMOSWRAP
VG1590 g1590 0 0.6000000000000000
RB1590 b1590 0 10
X1590 66 g1590 3 b1590 NMOSWRAP
VG1591 g1591 0 0.6000000000000000
RB1591 b1591 0 10
X1591 66 g1591 3 b1591 NMOSWRAP
VG1592 g1592 0 0.6000000000000000
RB1592 b1592 0 10
X1592 66 g1592 3 b1592 NMOSWRAP
VG1593 g1593 0 0.6000000000000000
RB1593 b1593 0 10
X1593 66 g1593 4 b1593 NMOSWRAP
VG1594 g1594 0 0.6000000000000000
RB1594 b1594 0 10
X1594 66 g1594 4 b1594 NMOSWRAP
VG1595 g1595 0 0.6000000000000000
RB1595 b1595 0 10
X1595 66 g1595 4 b1595 NMOSWRAP
VG1596 g1596 0 0.6000000000000000
RB1596 b1596 0 10
X1596 66 g1596 5 b1596 NMOSWRAP
VG1597 g1597 0 0.6000000000000000
RB1597 b1597 0 10
X1597 66 g1597 5 b1597 NMOSWRAP
VG1598 g1598 0 0.6000000000000000
RB1598 b1598 0 10
X1598 66 g1598 5 b1598 NMOSWRAP
VG1599 g1599 0 0.6000000000000000
RB1599 b1599 0 10
X1599 66 g1599 6 b1599 NMOSWRAP
VG1600 g1600 0 0.6000000000000000
RB1600 b1600 0 10
X1600 66 g1600 6 b1600 NMOSWRAP
VG1601 g1601 0 0.6000000000000000
RB1601 b1601 0 10
X1601 66 g1601 6 b1601 NMOSWRAP
VG1602 g1602 0 0.6000000000000000
RB1602 b1602 0 10
X1602 66 g1602 7 b1602 NMOSWRAP
VG1603 g1603 0 0.6000000000000000
RB1603 b1603 0 10
X1603 66 g1603 7 b1603 NMOSWRAP
VG1604 g1604 0 0.6000000000000000
RB1604 b1604 0 10
X1604 66 g1604 7 b1604 NMOSWRAP
VG1605 g1605 0 0.6000000000000000
RB1605 b1605 0 10
X1605 66 g1605 8 b1605 NMOSWRAP
VG1606 g1606 0 0.6000000000000000
RB1606 b1606 0 10
X1606 66 g1606 8 b1606 NMOSWRAP
VG1607 g1607 0 0.6000000000000000
RB1607 b1607 0 10
X1607 66 g1607 8 b1607 NMOSWRAP
VG1608 g1608 0 0.6000000000000000
RB1608 b1608 0 10
X1608 66 g1608 9 b1608 NMOSWRAP
VG1609 g1609 0 0.6000000000000000
RB1609 b1609 0 10
X1609 66 g1609 9 b1609 NMOSWRAP
VG1610 g1610 0 0.6000000000000000
RB1610 b1610 0 10
X1610 66 g1610 9 b1610 NMOSWRAP
VG1611 g1611 0 0.6000000000000000
RB1611 b1611 0 10
X1611 66 g1611 10 b1611 NMOSWRAP
VG1612 g1612 0 0.6000000000000000
RB1612 b1612 0 10
X1612 66 g1612 10 b1612 NMOSWRAP
VG1613 g1613 0 0.6000000000000000
RB1613 b1613 0 10
X1613 66 g1613 10 b1613 NMOSWRAP
VG1614 g1614 0 0.6000000000000000
RB1614 b1614 0 10
X1614 66 g1614 11 b1614 NMOSWRAP
VG1615 g1615 0 0.6000000000000000
RB1615 b1615 0 10
X1615 66 g1615 11 b1615 NMOSWRAP
VG1616 g1616 0 0.6000000000000000
RB1616 b1616 0 10
X1616 66 g1616 11 b1616 NMOSWRAP
VG1617 g1617 0 0.6000000000000000
RB1617 b1617 0 10
X1617 66 g1617 12 b1617 NMOSWRAP
VG1618 g1618 0 0.6000000000000000
RB1618 b1618 0 10
X1618 66 g1618 12 b1618 NMOSWRAP
VG1619 g1619 0 0.6000000000000000
RB1619 b1619 0 10
X1619 66 g1619 12 b1619 NMOSWRAP
VG1620 g1620 0 0.6000000000000000
RB1620 b1620 0 10
X1620 67 g1620 3 b1620 NMOSWRAP
VG1621 g1621 0 0.6000000000000000
RB1621 b1621 0 10
X1621 67 g1621 3 b1621 NMOSWRAP
VG1622 g1622 0 0.6000000000000000
RB1622 b1622 0 10
X1622 67 g1622 3 b1622 NMOSWRAP
VG1623 g1623 0 0.6000000000000000
RB1623 b1623 0 10
X1623 67 g1623 4 b1623 NMOSWRAP
VG1624 g1624 0 0.6000000000000000
RB1624 b1624 0 10
X1624 67 g1624 4 b1624 NMOSWRAP
VG1625 g1625 0 0.6000000000000000
RB1625 b1625 0 10
X1625 67 g1625 4 b1625 NMOSWRAP
VG1626 g1626 0 0.6000000000000000
RB1626 b1626 0 10
X1626 67 g1626 5 b1626 NMOSWRAP
VG1627 g1627 0 0.6000000000000000
RB1627 b1627 0 10
X1627 67 g1627 5 b1627 NMOSWRAP
VG1628 g1628 0 0.6000000000000000
RB1628 b1628 0 10
X1628 67 g1628 5 b1628 NMOSWRAP
VG1629 g1629 0 0.6000000000000000
RB1629 b1629 0 10
X1629 67 g1629 6 b1629 NMOSWRAP
VG1630 g1630 0 0.6000000000000000
RB1630 b1630 0 10
X1630 67 g1630 6 b1630 NMOSWRAP
VG1631 g1631 0 0.6000000000000000
RB1631 b1631 0 10
X1631 67 g1631 6 b1631 NMOSWRAP
VG1632 g1632 0 0.6000000000000000
RB1632 b1632 0 10
X1632 67 g1632 7 b1632 NMOSWRAP
VG1633 g1633 0 0.6000000000000000
RB1633 b1633 0 10
X1633 67 g1633 7 b1633 NMOSWRAP
VG1634 g1634 0 0.6000000000000000
RB1634 b1634 0 10
X1634 67 g1634 7 b1634 NMOSWRAP
VG1635 g1635 0 0.6000000000000000
RB1635 b1635 0 10
X1635 67 g1635 8 b1635 NMOSWRAP
VG1636 g1636 0 0.6000000000000000
RB1636 b1636 0 10
X1636 67 g1636 8 b1636 NMOSWRAP
VG1637 g1637 0 0.6000000000000000
RB1637 b1637 0 10
X1637 67 g1637 8 b1637 NMOSWRAP
VG1638 g1638 0 0.6000000000000000
RB1638 b1638 0 10
X1638 67 g1638 9 b1638 NMOSWRAP
VG1639 g1639 0 0.6000000000000000
RB1639 b1639 0 10
X1639 67 g1639 9 b1639 NMOSWRAP
VG1640 g1640 0 0.6000000000000000
RB1640 b1640 0 10
X1640 67 g1640 9 b1640 NMOSWRAP
VG1641 g1641 0 0.6000000000000000
RB1641 b1641 0 10
X1641 67 g1641 10 b1641 NMOSWRAP
VG1642 g1642 0 0.6000000000000000
RB1642 b1642 0 10
X1642 67 g1642 10 b1642 NMOSWRAP
VG1643 g1643 0 0.6000000000000000
RB1643 b1643 0 10
X1643 67 g1643 10 b1643 NMOSWRAP
VG1644 g1644 0 0.6000000000000000
RB1644 b1644 0 10
X1644 67 g1644 11 b1644 NMOSWRAP
VG1645 g1645 0 0.6000000000000000
RB1645 b1645 0 10
X1645 67 g1645 11 b1645 NMOSWRAP
VG1646 g1646 0 0.6000000000000000
RB1646 b1646 0 10
X1646 67 g1646 11 b1646 NMOSWRAP
VG1647 g1647 0 0.6000000000000000
RB1647 b1647 0 10
X1647 67 g1647 12 b1647 NMOSWRAP
VG1648 g1648 0 0.6000000000000000
RB1648 b1648 0 10
X1648 67 g1648 12 b1648 NMOSWRAP
VG1649 g1649 0 0.6000000000000000
RB1649 b1649 0 10
X1649 67 g1649 12 b1649 NMOSWRAP
VG1650 g1650 0 0.6000000000000000
RB1650 b1650 0 10
X1650 68 g1650 3 b1650 NMOSWRAP
VG1651 g1651 0 0.6000000000000000
RB1651 b1651 0 10
X1651 68 g1651 3 b1651 NMOSWRAP
VG1652 g1652 0 0.6000000000000000
RB1652 b1652 0 10
X1652 68 g1652 3 b1652 NMOSWRAP
VG1653 g1653 0 0.6000000000000000
RB1653 b1653 0 10
X1653 68 g1653 4 b1653 NMOSWRAP
VG1654 g1654 0 0.6000000000000000
RB1654 b1654 0 10
X1654 68 g1654 4 b1654 NMOSWRAP
VG1655 g1655 0 0.6000000000000000
RB1655 b1655 0 10
X1655 68 g1655 4 b1655 NMOSWRAP
VG1656 g1656 0 0.6000000000000000
RB1656 b1656 0 10
X1656 68 g1656 5 b1656 NMOSWRAP
VG1657 g1657 0 0.6000000000000000
RB1657 b1657 0 10
X1657 68 g1657 5 b1657 NMOSWRAP
VG1658 g1658 0 0.6000000000000000
RB1658 b1658 0 10
X1658 68 g1658 5 b1658 NMOSWRAP
VG1659 g1659 0 0.6000000000000000
RB1659 b1659 0 10
X1659 68 g1659 6 b1659 NMOSWRAP
VG1660 g1660 0 0.6000000000000000
RB1660 b1660 0 10
X1660 68 g1660 6 b1660 NMOSWRAP
VG1661 g1661 0 0.6000000000000000
RB1661 b1661 0 10
X1661 68 g1661 6 b1661 NMOSWRAP
VG1662 g1662 0 0.6000000000000000
RB1662 b1662 0 10
X1662 68 g1662 7 b1662 NMOSWRAP
VG1663 g1663 0 0.6000000000000000
RB1663 b1663 0 10
X1663 68 g1663 7 b1663 NMOSWRAP
VG1664 g1664 0 0.6000000000000000
RB1664 b1664 0 10
X1664 68 g1664 7 b1664 NMOSWRAP
VG1665 g1665 0 0.6000000000000000
RB1665 b1665 0 10
X1665 68 g1665 8 b1665 NMOSWRAP
VG1666 g1666 0 0.6000000000000000
RB1666 b1666 0 10
X1666 68 g1666 8 b1666 NMOSWRAP
VG1667 g1667 0 0.6000000000000000
RB1667 b1667 0 10
X1667 68 g1667 8 b1667 NMOSWRAP
VG1668 g1668 0 0.6000000000000000
RB1668 b1668 0 10
X1668 68 g1668 9 b1668 NMOSWRAP
VG1669 g1669 0 0.6000000000000000
RB1669 b1669 0 10
X1669 68 g1669 9 b1669 NMOSWRAP
VG1670 g1670 0 0.6000000000000000
RB1670 b1670 0 10
X1670 68 g1670 9 b1670 NMOSWRAP
VG1671 g1671 0 0.6000000000000000
RB1671 b1671 0 10
X1671 68 g1671 10 b1671 NMOSWRAP
VG1672 g1672 0 0.6000000000000000
RB1672 b1672 0 10
X1672 68 g1672 10 b1672 NMOSWRAP
VG1673 g1673 0 0.6000000000000000
RB1673 b1673 0 10
X1673 68 g1673 10 b1673 NMOSWRAP
VG1674 g1674 0 0.6000000000000000
RB1674 b1674 0 10
X1674 68 g1674 11 b1674 NMOSWRAP
VG1675 g1675 0 0.6000000000000000
RB1675 b1675 0 10
X1675 68 g1675 11 b1675 NMOSWRAP
VG1676 g1676 0 0.6000000000000000
RB1676 b1676 0 10
X1676 68 g1676 11 b1676 NMOSWRAP
VG1677 g1677 0 0.6000000000000000
RB1677 b1677 0 10
X1677 68 g1677 12 b1677 NMOSWRAP
VG1678 g1678 0 0.6000000000000000
RB1678 b1678 0 10
X1678 68 g1678 12 b1678 NMOSWRAP
VG1679 g1679 0 0.6000000000000000
RB1679 b1679 0 10
X1679 68 g1679 12 b1679 NMOSWRAP
VG1680 g1680 0 0.6000000000000000
RB1680 b1680 0 10
X1680 69 g1680 3 b1680 NMOSWRAP
VG1681 g1681 0 0.6000000000000000
RB1681 b1681 0 10
X1681 69 g1681 3 b1681 NMOSWRAP
VG1682 g1682 0 0.6000000000000000
RB1682 b1682 0 10
X1682 69 g1682 3 b1682 NMOSWRAP
VG1683 g1683 0 0.6000000000000000
RB1683 b1683 0 10
X1683 69 g1683 4 b1683 NMOSWRAP
VG1684 g1684 0 0.6000000000000000
RB1684 b1684 0 10
X1684 69 g1684 4 b1684 NMOSWRAP
VG1685 g1685 0 0.6000000000000000
RB1685 b1685 0 10
X1685 69 g1685 4 b1685 NMOSWRAP
VG1686 g1686 0 0.6000000000000000
RB1686 b1686 0 10
X1686 69 g1686 5 b1686 NMOSWRAP
VG1687 g1687 0 0.6000000000000000
RB1687 b1687 0 10
X1687 69 g1687 5 b1687 NMOSWRAP
VG1688 g1688 0 0.6000000000000000
RB1688 b1688 0 10
X1688 69 g1688 5 b1688 NMOSWRAP
VG1689 g1689 0 0.6000000000000000
RB1689 b1689 0 10
X1689 69 g1689 6 b1689 NMOSWRAP
VG1690 g1690 0 0.6000000000000000
RB1690 b1690 0 10
X1690 69 g1690 6 b1690 NMOSWRAP
VG1691 g1691 0 0.6000000000000000
RB1691 b1691 0 10
X1691 69 g1691 6 b1691 NMOSWRAP
VG1692 g1692 0 0.6000000000000000
RB1692 b1692 0 10
X1692 69 g1692 7 b1692 NMOSWRAP
VG1693 g1693 0 0.6000000000000000
RB1693 b1693 0 10
X1693 69 g1693 7 b1693 NMOSWRAP
VG1694 g1694 0 0.6000000000000000
RB1694 b1694 0 10
X1694 69 g1694 7 b1694 NMOSWRAP
VG1695 g1695 0 0.6000000000000000
RB1695 b1695 0 10
X1695 69 g1695 8 b1695 NMOSWRAP
VG1696 g1696 0 0.6000000000000000
RB1696 b1696 0 10
X1696 69 g1696 8 b1696 NMOSWRAP
VG1697 g1697 0 0.6000000000000000
RB1697 b1697 0 10
X1697 69 g1697 8 b1697 NMOSWRAP
VG1698 g1698 0 0.6000000000000000
RB1698 b1698 0 10
X1698 69 g1698 9 b1698 NMOSWRAP
VG1699 g1699 0 0.6000000000000000
RB1699 b1699 0 10
X1699 69 g1699 9 b1699 NMOSWRAP
VG1700 g1700 0 0.6000000000000000
RB1700 b1700 0 10
X1700 69 g1700 9 b1700 NMOSWRAP
VG1701 g1701 0 0.6000000000000000
RB1701 b1701 0 10
X1701 69 g1701 10 b1701 NMOSWRAP
VG1702 g1702 0 0.6000000000000000
RB1702 b1702 0 10
X1702 69 g1702 10 b1702 NMOSWRAP
VG1703 g1703 0 0.6000000000000000
RB1703 b1703 0 10
X1703 69 g1703 10 b1703 NMOSWRAP
VG1704 g1704 0 0.6000000000000000
RB1704 b1704 0 10
X1704 69 g1704 11 b1704 NMOSWRAP
VG1705 g1705 0 0.6000000000000000
RB1705 b1705 0 10
X1705 69 g1705 11 b1705 NMOSWRAP
VG1706 g1706 0 0.6000000000000000
RB1706 b1706 0 10
X1706 69 g1706 11 b1706 NMOSWRAP
VG1707 g1707 0 0.6000000000000000
RB1707 b1707 0 10
X1707 69 g1707 12 b1707 NMOSWRAP
VG1708 g1708 0 0.6000000000000000
RB1708 b1708 0 10
X1708 69 g1708 12 b1708 NMOSWRAP
VG1709 g1709 0 0.6000000000000000
RB1709 b1709 0 10
X1709 69 g1709 12 b1709 NMOSWRAP
VG1710 g1710 0 0.6000000000000000
RB1710 b1710 0 10
X1710 70 g1710 3 b1710 NMOSWRAP
VG1711 g1711 0 0.6000000000000000
RB1711 b1711 0 10
X1711 70 g1711 3 b1711 NMOSWRAP
VG1712 g1712 0 0.6000000000000000
RB1712 b1712 0 10
X1712 70 g1712 3 b1712 NMOSWRAP
VG1713 g1713 0 0.6000000000000000
RB1713 b1713 0 10
X1713 70 g1713 4 b1713 NMOSWRAP
VG1714 g1714 0 0.6000000000000000
RB1714 b1714 0 10
X1714 70 g1714 4 b1714 NMOSWRAP
VG1715 g1715 0 0.6000000000000000
RB1715 b1715 0 10
X1715 70 g1715 4 b1715 NMOSWRAP
VG1716 g1716 0 0.6000000000000000
RB1716 b1716 0 10
X1716 70 g1716 5 b1716 NMOSWRAP
VG1717 g1717 0 0.6000000000000000
RB1717 b1717 0 10
X1717 70 g1717 5 b1717 NMOSWRAP
VG1718 g1718 0 0.6000000000000000
RB1718 b1718 0 10
X1718 70 g1718 5 b1718 NMOSWRAP
VG1719 g1719 0 0.6000000000000000
RB1719 b1719 0 10
X1719 70 g1719 6 b1719 NMOSWRAP
VG1720 g1720 0 0.6000000000000000
RB1720 b1720 0 10
X1720 70 g1720 6 b1720 NMOSWRAP
VG1721 g1721 0 0.6000000000000000
RB1721 b1721 0 10
X1721 70 g1721 6 b1721 NMOSWRAP
VG1722 g1722 0 0.6000000000000000
RB1722 b1722 0 10
X1722 70 g1722 7 b1722 NMOSWRAP
VG1723 g1723 0 0.6000000000000000
RB1723 b1723 0 10
X1723 70 g1723 7 b1723 NMOSWRAP
VG1724 g1724 0 0.6000000000000000
RB1724 b1724 0 10
X1724 70 g1724 7 b1724 NMOSWRAP
VG1725 g1725 0 0.6000000000000000
RB1725 b1725 0 10
X1725 70 g1725 8 b1725 NMOSWRAP
VG1726 g1726 0 0.6000000000000000
RB1726 b1726 0 10
X1726 70 g1726 8 b1726 NMOSWRAP
VG1727 g1727 0 0.6000000000000000
RB1727 b1727 0 10
X1727 70 g1727 8 b1727 NMOSWRAP
VG1728 g1728 0 0.6000000000000000
RB1728 b1728 0 10
X1728 70 g1728 9 b1728 NMOSWRAP
VG1729 g1729 0 0.6000000000000000
RB1729 b1729 0 10
X1729 70 g1729 9 b1729 NMOSWRAP
VG1730 g1730 0 0.6000000000000000
RB1730 b1730 0 10
X1730 70 g1730 9 b1730 NMOSWRAP
VG1731 g1731 0 0.6000000000000000
RB1731 b1731 0 10
X1731 70 g1731 10 b1731 NMOSWRAP
VG1732 g1732 0 0.6000000000000000
RB1732 b1732 0 10
X1732 70 g1732 10 b1732 NMOSWRAP
VG1733 g1733 0 0.6000000000000000
RB1733 b1733 0 10
X1733 70 g1733 10 b1733 NMOSWRAP
VG1734 g1734 0 0.6000000000000000
RB1734 b1734 0 10
X1734 70 g1734 11 b1734 NMOSWRAP
VG1735 g1735 0 0.6000000000000000
RB1735 b1735 0 10
X1735 70 g1735 11 b1735 NMOSWRAP
VG1736 g1736 0 0.6000000000000000
RB1736 b1736 0 10
X1736 70 g1736 11 b1736 NMOSWRAP
VG1737 g1737 0 0.6000000000000000
RB1737 b1737 0 10
X1737 70 g1737 12 b1737 NMOSWRAP
VG1738 g1738 0 0.6000000000000000
RB1738 b1738 0 10
X1738 70 g1738 12 b1738 NMOSWRAP
VG1739 g1739 0 0.6000000000000000
RB1739 b1739 0 10
X1739 70 g1739 12 b1739 NMOSWRAP
VG1740 g1740 0 0.6000000000000000
RB1740 b1740 0 10
X1740 71 g1740 3 b1740 NMOSWRAP
VG1741 g1741 0 0.6000000000000000
RB1741 b1741 0 10
X1741 71 g1741 3 b1741 NMOSWRAP
VG1742 g1742 0 0.6000000000000000
RB1742 b1742 0 10
X1742 71 g1742 3 b1742 NMOSWRAP
VG1743 g1743 0 0.6000000000000000
RB1743 b1743 0 10
X1743 71 g1743 4 b1743 NMOSWRAP
VG1744 g1744 0 0.6000000000000000
RB1744 b1744 0 10
X1744 71 g1744 4 b1744 NMOSWRAP
VG1745 g1745 0 0.6000000000000000
RB1745 b1745 0 10
X1745 71 g1745 4 b1745 NMOSWRAP
VG1746 g1746 0 0.6000000000000000
RB1746 b1746 0 10
X1746 71 g1746 5 b1746 NMOSWRAP
VG1747 g1747 0 0.6000000000000000
RB1747 b1747 0 10
X1747 71 g1747 5 b1747 NMOSWRAP
VG1748 g1748 0 0.6000000000000000
RB1748 b1748 0 10
X1748 71 g1748 5 b1748 NMOSWRAP
VG1749 g1749 0 0.6000000000000000
RB1749 b1749 0 10
X1749 71 g1749 6 b1749 NMOSWRAP
VG1750 g1750 0 0.6000000000000000
RB1750 b1750 0 10
X1750 71 g1750 6 b1750 NMOSWRAP
VG1751 g1751 0 0.6000000000000000
RB1751 b1751 0 10
X1751 71 g1751 6 b1751 NMOSWRAP
VG1752 g1752 0 0.6000000000000000
RB1752 b1752 0 10
X1752 71 g1752 7 b1752 NMOSWRAP
VG1753 g1753 0 0.6000000000000000
RB1753 b1753 0 10
X1753 71 g1753 7 b1753 NMOSWRAP
VG1754 g1754 0 0.6000000000000000
RB1754 b1754 0 10
X1754 71 g1754 7 b1754 NMOSWRAP
VG1755 g1755 0 0.6000000000000000
RB1755 b1755 0 10
X1755 71 g1755 8 b1755 NMOSWRAP
VG1756 g1756 0 0.6000000000000000
RB1756 b1756 0 10
X1756 71 g1756 8 b1756 NMOSWRAP
VG1757 g1757 0 0.6000000000000000
RB1757 b1757 0 10
X1757 71 g1757 8 b1757 NMOSWRAP
VG1758 g1758 0 0.6000000000000000
RB1758 b1758 0 10
X1758 71 g1758 9 b1758 NMOSWRAP
VG1759 g1759 0 0.6000000000000000
RB1759 b1759 0 10
X1759 71 g1759 9 b1759 NMOSWRAP
VG1760 g1760 0 0.6000000000000000
RB1760 b1760 0 10
X1760 71 g1760 9 b1760 NMOSWRAP
VG1761 g1761 0 0.6000000000000000
RB1761 b1761 0 10
X1761 71 g1761 10 b1761 NMOSWRAP
VG1762 g1762 0 0.6000000000000000
RB1762 b1762 0 10
X1762 71 g1762 10 b1762 NMOSWRAP
VG1763 g1763 0 0.6000000000000000
RB1763 b1763 0 10
X1763 71 g1763 10 b1763 NMOSWRAP
VG1764 g1764 0 0.6000000000000000
RB1764 b1764 0 10
X1764 71 g1764 11 b1764 NMOSWRAP
VG1765 g1765 0 0.6000000000000000
RB1765 b1765 0 10
X1765 71 g1765 11 b1765 NMOSWRAP
VG1766 g1766 0 0.6000000000000000
RB1766 b1766 0 10
X1766 71 g1766 11 b1766 NMOSWRAP
VG1767 g1767 0 0.6000000000000000
RB1767 b1767 0 10
X1767 71 g1767 12 b1767 NMOSWRAP
VG1768 g1768 0 0.6000000000000000
RB1768 b1768 0 10
X1768 71 g1768 12 b1768 NMOSWRAP
VG1769 g1769 0 0.6000000000000000
RB1769 b1769 0 10
X1769 71 g1769 12 b1769 NMOSWRAP
VG1770 g1770 0 0.6000000000000000
RB1770 b1770 0 10
X1770 72 g1770 3 b1770 NMOSWRAP
VG1771 g1771 0 0.6000000000000000
RB1771 b1771 0 10
X1771 72 g1771 3 b1771 NMOSWRAP
VG1772 g1772 0 0.6000000000000000
RB1772 b1772 0 10
X1772 72 g1772 3 b1772 NMOSWRAP
VG1773 g1773 0 0.6000000000000000
RB1773 b1773 0 10
X1773 72 g1773 4 b1773 NMOSWRAP
VG1774 g1774 0 0.6000000000000000
RB1774 b1774 0 10
X1774 72 g1774 4 b1774 NMOSWRAP
VG1775 g1775 0 0.6000000000000000
RB1775 b1775 0 10
X1775 72 g1775 4 b1775 NMOSWRAP
VG1776 g1776 0 0.6000000000000000
RB1776 b1776 0 10
X1776 72 g1776 5 b1776 NMOSWRAP
VG1777 g1777 0 0.6000000000000000
RB1777 b1777 0 10
X1777 72 g1777 5 b1777 NMOSWRAP
VG1778 g1778 0 0.6000000000000000
RB1778 b1778 0 10
X1778 72 g1778 5 b1778 NMOSWRAP
VG1779 g1779 0 0.6000000000000000
RB1779 b1779 0 10
X1779 72 g1779 6 b1779 NMOSWRAP
VG1780 g1780 0 0.6000000000000000
RB1780 b1780 0 10
X1780 72 g1780 6 b1780 NMOSWRAP
VG1781 g1781 0 0.6000000000000000
RB1781 b1781 0 10
X1781 72 g1781 6 b1781 NMOSWRAP
VG1782 g1782 0 0.6000000000000000
RB1782 b1782 0 10
X1782 72 g1782 7 b1782 NMOSWRAP
VG1783 g1783 0 0.6000000000000000
RB1783 b1783 0 10
X1783 72 g1783 7 b1783 NMOSWRAP
VG1784 g1784 0 0.6000000000000000
RB1784 b1784 0 10
X1784 72 g1784 7 b1784 NMOSWRAP
VG1785 g1785 0 0.6000000000000000
RB1785 b1785 0 10
X1785 72 g1785 8 b1785 NMOSWRAP
VG1786 g1786 0 0.6000000000000000
RB1786 b1786 0 10
X1786 72 g1786 8 b1786 NMOSWRAP
VG1787 g1787 0 0.6000000000000000
RB1787 b1787 0 10
X1787 72 g1787 8 b1787 NMOSWRAP
VG1788 g1788 0 0.6000000000000000
RB1788 b1788 0 10
X1788 72 g1788 9 b1788 NMOSWRAP
VG1789 g1789 0 0.6000000000000000
RB1789 b1789 0 10
X1789 72 g1789 9 b1789 NMOSWRAP
VG1790 g1790 0 0.6000000000000000
RB1790 b1790 0 10
X1790 72 g1790 9 b1790 NMOSWRAP
VG1791 g1791 0 0.6000000000000000
RB1791 b1791 0 10
X1791 72 g1791 10 b1791 NMOSWRAP
VG1792 g1792 0 0.6000000000000000
RB1792 b1792 0 10
X1792 72 g1792 10 b1792 NMOSWRAP
VG1793 g1793 0 0.6000000000000000
RB1793 b1793 0 10
X1793 72 g1793 10 b1793 NMOSWRAP
VG1794 g1794 0 0.6000000000000000
RB1794 b1794 0 10
X1794 72 g1794 11 b1794 NMOSWRAP
VG1795 g1795 0 0.6000000000000000
RB1795 b1795 0 10
X1795 72 g1795 11 b1795 NMOSWRAP
VG1796 g1796 0 0.6000000000000000
RB1796 b1796 0 10
X1796 72 g1796 11 b1796 NMOSWRAP
VG1797 g1797 0 0.6000000000000000
RB1797 b1797 0 10
X1797 72 g1797 12 b1797 NMOSWRAP
VG1798 g1798 0 0.6000000000000000
RB1798 b1798 0 10
X1798 72 g1798 12 b1798 NMOSWRAP
VG1799 g1799 0 0.6000000000000000
RB1799 b1799 0 10
X1799 72 g1799 12 b1799 NMOSWRAP
VG1800 g1800 0 0.6000000000000000
RB1800 b1800 0 10
X1800 73 g1800 3 b1800 NMOSWRAP
VG1801 g1801 0 0.6000000000000000
RB1801 b1801 0 10
X1801 73 g1801 3 b1801 NMOSWRAP
VG1802 g1802 0 0.6000000000000000
RB1802 b1802 0 10
X1802 73 g1802 3 b1802 NMOSWRAP
VG1803 g1803 0 0.6000000000000000
RB1803 b1803 0 10
X1803 73 g1803 4 b1803 NMOSWRAP
VG1804 g1804 0 0.6000000000000000
RB1804 b1804 0 10
X1804 73 g1804 4 b1804 NMOSWRAP
VG1805 g1805 0 0.6000000000000000
RB1805 b1805 0 10
X1805 73 g1805 4 b1805 NMOSWRAP
VG1806 g1806 0 0.6000000000000000
RB1806 b1806 0 10
X1806 73 g1806 5 b1806 NMOSWRAP
VG1807 g1807 0 0.6000000000000000
RB1807 b1807 0 10
X1807 73 g1807 5 b1807 NMOSWRAP
VG1808 g1808 0 0.6000000000000000
RB1808 b1808 0 10
X1808 73 g1808 5 b1808 NMOSWRAP
VG1809 g1809 0 0.6000000000000000
RB1809 b1809 0 10
X1809 73 g1809 6 b1809 NMOSWRAP
VG1810 g1810 0 0.6000000000000000
RB1810 b1810 0 10
X1810 73 g1810 6 b1810 NMOSWRAP
VG1811 g1811 0 0.6000000000000000
RB1811 b1811 0 10
X1811 73 g1811 6 b1811 NMOSWRAP
VG1812 g1812 0 0.6000000000000000
RB1812 b1812 0 10
X1812 73 g1812 7 b1812 NMOSWRAP
VG1813 g1813 0 0.6000000000000000
RB1813 b1813 0 10
X1813 73 g1813 7 b1813 NMOSWRAP
VG1814 g1814 0 0.6000000000000000
RB1814 b1814 0 10
X1814 73 g1814 7 b1814 NMOSWRAP
VG1815 g1815 0 0.6000000000000000
RB1815 b1815 0 10
X1815 73 g1815 8 b1815 NMOSWRAP
VG1816 g1816 0 0.6000000000000000
RB1816 b1816 0 10
X1816 73 g1816 8 b1816 NMOSWRAP
VG1817 g1817 0 0.6000000000000000
RB1817 b1817 0 10
X1817 73 g1817 8 b1817 NMOSWRAP
VG1818 g1818 0 0.6000000000000000
RB1818 b1818 0 10
X1818 73 g1818 9 b1818 NMOSWRAP
VG1819 g1819 0 0.6000000000000000
RB1819 b1819 0 10
X1819 73 g1819 9 b1819 NMOSWRAP
VG1820 g1820 0 0.6000000000000000
RB1820 b1820 0 10
X1820 73 g1820 9 b1820 NMOSWRAP
VG1821 g1821 0 0.6000000000000000
RB1821 b1821 0 10
X1821 73 g1821 10 b1821 NMOSWRAP
VG1822 g1822 0 0.6000000000000000
RB1822 b1822 0 10
X1822 73 g1822 10 b1822 NMOSWRAP
VG1823 g1823 0 0.6000000000000000
RB1823 b1823 0 10
X1823 73 g1823 10 b1823 NMOSWRAP
VG1824 g1824 0 0.6000000000000000
RB1824 b1824 0 10
X1824 73 g1824 11 b1824 NMOSWRAP
VG1825 g1825 0 0.6000000000000000
RB1825 b1825 0 10
X1825 73 g1825 11 b1825 NMOSWRAP
VG1826 g1826 0 0.6000000000000000
RB1826 b1826 0 10
X1826 73 g1826 11 b1826 NMOSWRAP
VG1827 g1827 0 0.6000000000000000
RB1827 b1827 0 10
X1827 73 g1827 12 b1827 NMOSWRAP
VG1828 g1828 0 0.6000000000000000
RB1828 b1828 0 10
X1828 73 g1828 12 b1828 NMOSWRAP
VG1829 g1829 0 0.6000000000000000
RB1829 b1829 0 10
X1829 73 g1829 12 b1829 NMOSWRAP
VG1830 g1830 0 0.6000000000000000
RB1830 b1830 0 10
X1830 74 g1830 3 b1830 NMOSWRAP
VG1831 g1831 0 0.6000000000000000
RB1831 b1831 0 10
X1831 74 g1831 3 b1831 NMOSWRAP
VG1832 g1832 0 0.6000000000000000
RB1832 b1832 0 10
X1832 74 g1832 3 b1832 NMOSWRAP
VG1833 g1833 0 0.6000000000000000
RB1833 b1833 0 10
X1833 74 g1833 4 b1833 NMOSWRAP
VG1834 g1834 0 0.6000000000000000
RB1834 b1834 0 10
X1834 74 g1834 4 b1834 NMOSWRAP
VG1835 g1835 0 0.6000000000000000
RB1835 b1835 0 10
X1835 74 g1835 4 b1835 NMOSWRAP
VG1836 g1836 0 0.6000000000000000
RB1836 b1836 0 10
X1836 74 g1836 5 b1836 NMOSWRAP
VG1837 g1837 0 0.6000000000000000
RB1837 b1837 0 10
X1837 74 g1837 5 b1837 NMOSWRAP
VG1838 g1838 0 0.6000000000000000
RB1838 b1838 0 10
X1838 74 g1838 5 b1838 NMOSWRAP
VG1839 g1839 0 0.6000000000000000
RB1839 b1839 0 10
X1839 74 g1839 6 b1839 NMOSWRAP
VG1840 g1840 0 0.6000000000000000
RB1840 b1840 0 10
X1840 74 g1840 6 b1840 NMOSWRAP
VG1841 g1841 0 0.6000000000000000
RB1841 b1841 0 10
X1841 74 g1841 6 b1841 NMOSWRAP
VG1842 g1842 0 0.6000000000000000
RB1842 b1842 0 10
X1842 74 g1842 7 b1842 NMOSWRAP
VG1843 g1843 0 0.6000000000000000
RB1843 b1843 0 10
X1843 74 g1843 7 b1843 NMOSWRAP
VG1844 g1844 0 0.6000000000000000
RB1844 b1844 0 10
X1844 74 g1844 7 b1844 NMOSWRAP
VG1845 g1845 0 0.6000000000000000
RB1845 b1845 0 10
X1845 74 g1845 8 b1845 NMOSWRAP
VG1846 g1846 0 0.6000000000000000
RB1846 b1846 0 10
X1846 74 g1846 8 b1846 NMOSWRAP
VG1847 g1847 0 0.6000000000000000
RB1847 b1847 0 10
X1847 74 g1847 8 b1847 NMOSWRAP
VG1848 g1848 0 0.6000000000000000
RB1848 b1848 0 10
X1848 74 g1848 9 b1848 NMOSWRAP
VG1849 g1849 0 0.6000000000000000
RB1849 b1849 0 10
X1849 74 g1849 9 b1849 NMOSWRAP
VG1850 g1850 0 0.6000000000000000
RB1850 b1850 0 10
X1850 74 g1850 9 b1850 NMOSWRAP
VG1851 g1851 0 0.6000000000000000
RB1851 b1851 0 10
X1851 74 g1851 10 b1851 NMOSWRAP
VG1852 g1852 0 0.6000000000000000
RB1852 b1852 0 10
X1852 74 g1852 10 b1852 NMOSWRAP
VG1853 g1853 0 0.6000000000000000
RB1853 b1853 0 10
X1853 74 g1853 10 b1853 NMOSWRAP
VG1854 g1854 0 0.6000000000000000
RB1854 b1854 0 10
X1854 74 g1854 11 b1854 NMOSWRAP
VG1855 g1855 0 0.6000000000000000
RB1855 b1855 0 10
X1855 74 g1855 11 b1855 NMOSWRAP
VG1856 g1856 0 0.6000000000000000
RB1856 b1856 0 10
X1856 74 g1856 11 b1856 NMOSWRAP
VG1857 g1857 0 0.6000000000000000
RB1857 b1857 0 10
X1857 74 g1857 12 b1857 NMOSWRAP
VG1858 g1858 0 0.6000000000000000
RB1858 b1858 0 10
X1858 74 g1858 12 b1858 NMOSWRAP
VG1859 g1859 0 0.6000000000000000
RB1859 b1859 0 10
X1859 74 g1859 12 b1859 NMOSWRAP
VG1860 g1860 0 0.6000000000000000
RB1860 b1860 0 10
X1860 75 g1860 3 b1860 NMOSWRAP
VG1861 g1861 0 0.6000000000000000
RB1861 b1861 0 10
X1861 75 g1861 3 b1861 NMOSWRAP
VG1862 g1862 0 0.6000000000000000
RB1862 b1862 0 10
X1862 75 g1862 3 b1862 NMOSWRAP
VG1863 g1863 0 0.6000000000000000
RB1863 b1863 0 10
X1863 75 g1863 4 b1863 NMOSWRAP
VG1864 g1864 0 0.6000000000000000
RB1864 b1864 0 10
X1864 75 g1864 4 b1864 NMOSWRAP
VG1865 g1865 0 0.6000000000000000
RB1865 b1865 0 10
X1865 75 g1865 4 b1865 NMOSWRAP
VG1866 g1866 0 0.6000000000000000
RB1866 b1866 0 10
X1866 75 g1866 5 b1866 NMOSWRAP
VG1867 g1867 0 0.6000000000000000
RB1867 b1867 0 10
X1867 75 g1867 5 b1867 NMOSWRAP
VG1868 g1868 0 0.6000000000000000
RB1868 b1868 0 10
X1868 75 g1868 5 b1868 NMOSWRAP
VG1869 g1869 0 0.6000000000000000
RB1869 b1869 0 10
X1869 75 g1869 6 b1869 NMOSWRAP
VG1870 g1870 0 0.6000000000000000
RB1870 b1870 0 10
X1870 75 g1870 6 b1870 NMOSWRAP
VG1871 g1871 0 0.6000000000000000
RB1871 b1871 0 10
X1871 75 g1871 6 b1871 NMOSWRAP
VG1872 g1872 0 0.6000000000000000
RB1872 b1872 0 10
X1872 75 g1872 7 b1872 NMOSWRAP
VG1873 g1873 0 0.6000000000000000
RB1873 b1873 0 10
X1873 75 g1873 7 b1873 NMOSWRAP
VG1874 g1874 0 0.6000000000000000
RB1874 b1874 0 10
X1874 75 g1874 7 b1874 NMOSWRAP
VG1875 g1875 0 0.6000000000000000
RB1875 b1875 0 10
X1875 75 g1875 8 b1875 NMOSWRAP
VG1876 g1876 0 0.6000000000000000
RB1876 b1876 0 10
X1876 75 g1876 8 b1876 NMOSWRAP
VG1877 g1877 0 0.6000000000000000
RB1877 b1877 0 10
X1877 75 g1877 8 b1877 NMOSWRAP
VG1878 g1878 0 0.6000000000000000
RB1878 b1878 0 10
X1878 75 g1878 9 b1878 NMOSWRAP
VG1879 g1879 0 0.6000000000000000
RB1879 b1879 0 10
X1879 75 g1879 9 b1879 NMOSWRAP
VG1880 g1880 0 0.6000000000000000
RB1880 b1880 0 10
X1880 75 g1880 9 b1880 NMOSWRAP
VG1881 g1881 0 0.6000000000000000
RB1881 b1881 0 10
X1881 75 g1881 10 b1881 NMOSWRAP
VG1882 g1882 0 0.6000000000000000
RB1882 b1882 0 10
X1882 75 g1882 10 b1882 NMOSWRAP
VG1883 g1883 0 0.6000000000000000
RB1883 b1883 0 10
X1883 75 g1883 10 b1883 NMOSWRAP
VG1884 g1884 0 0.6000000000000000
RB1884 b1884 0 10
X1884 75 g1884 11 b1884 NMOSWRAP
VG1885 g1885 0 0.6000000000000000
RB1885 b1885 0 10
X1885 75 g1885 11 b1885 NMOSWRAP
VG1886 g1886 0 0.6000000000000000
RB1886 b1886 0 10
X1886 75 g1886 11 b1886 NMOSWRAP
VG1887 g1887 0 0.6000000000000000
RB1887 b1887 0 10
X1887 75 g1887 12 b1887 NMOSWRAP
VG1888 g1888 0 0.6000000000000000
RB1888 b1888 0 10
X1888 75 g1888 12 b1888 NMOSWRAP
VG1889 g1889 0 0.6000000000000000
RB1889 b1889 0 10
X1889 75 g1889 12 b1889 NMOSWRAP
VG1890 g1890 0 0.6000000000000000
RB1890 b1890 0 10
X1890 76 g1890 3 b1890 NMOSWRAP
VG1891 g1891 0 0.6000000000000000
RB1891 b1891 0 10
X1891 76 g1891 3 b1891 NMOSWRAP
VG1892 g1892 0 0.6000000000000000
RB1892 b1892 0 10
X1892 76 g1892 3 b1892 NMOSWRAP
VG1893 g1893 0 0.6000000000000000
RB1893 b1893 0 10
X1893 76 g1893 4 b1893 NMOSWRAP
VG1894 g1894 0 0.6000000000000000
RB1894 b1894 0 10
X1894 76 g1894 4 b1894 NMOSWRAP
VG1895 g1895 0 0.6000000000000000
RB1895 b1895 0 10
X1895 76 g1895 4 b1895 NMOSWRAP
VG1896 g1896 0 0.6000000000000000
RB1896 b1896 0 10
X1896 76 g1896 5 b1896 NMOSWRAP
VG1897 g1897 0 0.6000000000000000
RB1897 b1897 0 10
X1897 76 g1897 5 b1897 NMOSWRAP
VG1898 g1898 0 0.6000000000000000
RB1898 b1898 0 10
X1898 76 g1898 5 b1898 NMOSWRAP
VG1899 g1899 0 0.6000000000000000
RB1899 b1899 0 10
X1899 76 g1899 6 b1899 NMOSWRAP
VG1900 g1900 0 0.6000000000000000
RB1900 b1900 0 10
X1900 76 g1900 6 b1900 NMOSWRAP
VG1901 g1901 0 0.6000000000000000
RB1901 b1901 0 10
X1901 76 g1901 6 b1901 NMOSWRAP
VG1902 g1902 0 0.6000000000000000
RB1902 b1902 0 10
X1902 76 g1902 7 b1902 NMOSWRAP
VG1903 g1903 0 0.6000000000000000
RB1903 b1903 0 10
X1903 76 g1903 7 b1903 NMOSWRAP
VG1904 g1904 0 0.6000000000000000
RB1904 b1904 0 10
X1904 76 g1904 7 b1904 NMOSWRAP
VG1905 g1905 0 0.6000000000000000
RB1905 b1905 0 10
X1905 76 g1905 8 b1905 NMOSWRAP
VG1906 g1906 0 0.6000000000000000
RB1906 b1906 0 10
X1906 76 g1906 8 b1906 NMOSWRAP
VG1907 g1907 0 0.6000000000000000
RB1907 b1907 0 10
X1907 76 g1907 8 b1907 NMOSWRAP
VG1908 g1908 0 0.6000000000000000
RB1908 b1908 0 10
X1908 76 g1908 9 b1908 NMOSWRAP
VG1909 g1909 0 0.6000000000000000
RB1909 b1909 0 10
X1909 76 g1909 9 b1909 NMOSWRAP
VG1910 g1910 0 0.6000000000000000
RB1910 b1910 0 10
X1910 76 g1910 9 b1910 NMOSWRAP
VG1911 g1911 0 0.6000000000000000
RB1911 b1911 0 10
X1911 76 g1911 10 b1911 NMOSWRAP
VG1912 g1912 0 0.6000000000000000
RB1912 b1912 0 10
X1912 76 g1912 10 b1912 NMOSWRAP
VG1913 g1913 0 0.6000000000000000
RB1913 b1913 0 10
X1913 76 g1913 10 b1913 NMOSWRAP
VG1914 g1914 0 0.6000000000000000
RB1914 b1914 0 10
X1914 76 g1914 11 b1914 NMOSWRAP
VG1915 g1915 0 0.6000000000000000
RB1915 b1915 0 10
X1915 76 g1915 11 b1915 NMOSWRAP
VG1916 g1916 0 0.6000000000000000
RB1916 b1916 0 10
X1916 76 g1916 11 b1916 NMOSWRAP
VG1917 g1917 0 0.6000000000000000
RB1917 b1917 0 10
X1917 76 g1917 12 b1917 NMOSWRAP
VG1918 g1918 0 0.6000000000000000
RB1918 b1918 0 10
X1918 76 g1918 12 b1918 NMOSWRAP
VG1919 g1919 0 0.6000000000000000
RB1919 b1919 0 10
X1919 76 g1919 12 b1919 NMOSWRAP
.options TEMP = 27C
.options TNOM = 27C
.options itl1=40 itl2=40 itl4=6 itl5=60
.options gmin=1e-8 reltol=5e-3 abstol=1e-8 vntol=1e-5
.options rshunt=1e9
.op
.end
